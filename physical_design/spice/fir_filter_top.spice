* NGSPICE file created from fir_filter_top.ext - technology: sky130A

* Black-box entry subcircuit for sky130_fd_sc_hd__tapvpwrvgnd_1 abstract view
.subckt sky130_fd_sc_hd__tapvpwrvgnd_1 VGND VPWR
.ends

* Black-box entry subcircuit for sky130_fd_sc_hd__fill_1 abstract view
.subckt sky130_fd_sc_hd__fill_1 VGND VNB VPB VPWR
.ends

* Black-box entry subcircuit for sky130_fd_sc_hd__nor2_1 abstract view
.subckt sky130_fd_sc_hd__nor2_1 A B VGND VNB VPB VPWR Y
.ends

* Black-box entry subcircuit for sky130_fd_sc_hd__fill_2 abstract view
.subckt sky130_fd_sc_hd__fill_2 VGND VNB VPB VPWR
.ends

* Black-box entry subcircuit for sky130_fd_sc_hd__nor3_1 abstract view
.subckt sky130_fd_sc_hd__nor3_1 A B C VGND VNB VPB VPWR Y
.ends

* Black-box entry subcircuit for sky130_fd_sc_hd__nand2_1 abstract view
.subckt sky130_fd_sc_hd__nand2_1 A B VGND VNB VPB VPWR Y
.ends

* Black-box entry subcircuit for sky130_fd_sc_hd__decap_3 abstract view
.subckt sky130_fd_sc_hd__decap_3 VGND VNB VPB VPWR
.ends

* Black-box entry subcircuit for sky130_ef_sc_hd__decap_12 abstract view
.subckt sky130_ef_sc_hd__decap_12 VPWR VGND VPB VNB
.ends

* Black-box entry subcircuit for sky130_fd_sc_hd__decap_4 abstract view
.subckt sky130_fd_sc_hd__decap_4 VGND VNB VPB VPWR
.ends

* Black-box entry subcircuit for sky130_fd_sc_hd__xnor2_1 abstract view
.subckt sky130_fd_sc_hd__xnor2_1 A B VGND VNB VPB VPWR Y
.ends

* Black-box entry subcircuit for sky130_fd_sc_hd__or2_1 abstract view
.subckt sky130_fd_sc_hd__or2_1 A B VGND VNB VPB VPWR X
.ends

* Black-box entry subcircuit for sky130_fd_sc_hd__decap_6 abstract view
.subckt sky130_fd_sc_hd__decap_6 VGND VNB VPB VPWR
.ends

* Black-box entry subcircuit for sky130_fd_sc_hd__nand2b_1 abstract view
.subckt sky130_fd_sc_hd__nand2b_1 A_N B VGND VNB VPB VPWR Y
.ends

* Black-box entry subcircuit for sky130_fd_sc_hd__clkbuf_1 abstract view
.subckt sky130_fd_sc_hd__clkbuf_1 A VGND VNB VPB VPWR X
.ends

* Black-box entry subcircuit for sky130_fd_sc_hd__decap_8 abstract view
.subckt sky130_fd_sc_hd__decap_8 VGND VNB VPB VPWR
.ends

* Black-box entry subcircuit for sky130_fd_sc_hd__dlygate4sd3_1 abstract view
.subckt sky130_fd_sc_hd__dlygate4sd3_1 A VGND VNB VPB VPWR X
.ends

* Black-box entry subcircuit for sky130_fd_sc_hd__and2b_1 abstract view
.subckt sky130_fd_sc_hd__and2b_1 A_N B VGND VNB VPB VPWR X
.ends

* Black-box entry subcircuit for sky130_fd_sc_hd__dfxtp_1 abstract view
.subckt sky130_fd_sc_hd__dfxtp_1 CLK D VGND VNB VPB VPWR Q
.ends

* Black-box entry subcircuit for sky130_fd_sc_hd__buf_2 abstract view
.subckt sky130_fd_sc_hd__buf_2 A VGND VNB VPB VPWR X
.ends

* Black-box entry subcircuit for sky130_fd_sc_hd__o21ai_1 abstract view
.subckt sky130_fd_sc_hd__o21ai_1 A1 A2 B1 VGND VNB VPB VPWR Y
.ends

* Black-box entry subcircuit for sky130_fd_sc_hd__o21a_1 abstract view
.subckt sky130_fd_sc_hd__o21a_1 A1 A2 B1 VGND VNB VPB VPWR X
.ends

* Black-box entry subcircuit for sky130_fd_sc_hd__o221a_1 abstract view
.subckt sky130_fd_sc_hd__o221a_1 A1 A2 B1 B2 C1 VGND VNB VPB VPWR X
.ends

* Black-box entry subcircuit for sky130_fd_sc_hd__a31o_1 abstract view
.subckt sky130_fd_sc_hd__a31o_1 A1 A2 A3 B1 VGND VNB VPB VPWR X
.ends

* Black-box entry subcircuit for sky130_fd_sc_hd__xor2_1 abstract view
.subckt sky130_fd_sc_hd__xor2_1 A B VGND VNB VPB VPWR X
.ends

* Black-box entry subcircuit for sky130_fd_sc_hd__or3_1 abstract view
.subckt sky130_fd_sc_hd__or3_1 A B C VGND VNB VPB VPWR X
.ends

* Black-box entry subcircuit for sky130_fd_sc_hd__and3_1 abstract view
.subckt sky130_fd_sc_hd__and3_1 A B C VGND VNB VPB VPWR X
.ends

* Black-box entry subcircuit for sky130_fd_sc_hd__nand3_1 abstract view
.subckt sky130_fd_sc_hd__nand3_1 A B C VGND VNB VPB VPWR Y
.ends

* Black-box entry subcircuit for sky130_fd_sc_hd__and2_1 abstract view
.subckt sky130_fd_sc_hd__and2_1 A B VGND VNB VPB VPWR X
.ends

* Black-box entry subcircuit for sky130_fd_sc_hd__a21oi_1 abstract view
.subckt sky130_fd_sc_hd__a21oi_1 A1 A2 B1 VGND VNB VPB VPWR Y
.ends

* Black-box entry subcircuit for sky130_fd_sc_hd__clkinv_2 abstract view
.subckt sky130_fd_sc_hd__clkinv_2 A VGND VNB VPB VPWR Y
.ends

* Black-box entry subcircuit for sky130_fd_sc_hd__a22o_1 abstract view
.subckt sky130_fd_sc_hd__a22o_1 A1 A2 B1 B2 VGND VNB VPB VPWR X
.ends

* Black-box entry subcircuit for sky130_fd_sc_hd__clkinvlp_4 abstract view
.subckt sky130_fd_sc_hd__clkinvlp_4 A VGND VNB VPB VPWR Y
.ends

* Black-box entry subcircuit for sky130_fd_sc_hd__a311o_1 abstract view
.subckt sky130_fd_sc_hd__a311o_1 A1 A2 A3 B1 C1 VGND VNB VPB VPWR X
.ends

* Black-box entry subcircuit for sky130_fd_sc_hd__a21o_1 abstract view
.subckt sky130_fd_sc_hd__a21o_1 A1 A2 B1 VGND VNB VPB VPWR X
.ends

* Black-box entry subcircuit for sky130_fd_sc_hd__o211ai_2 abstract view
.subckt sky130_fd_sc_hd__o211ai_2 A1 A2 B1 C1 VGND VNB VPB VPWR Y
.ends

* Black-box entry subcircuit for sky130_fd_sc_hd__clkbuf_16 abstract view
.subckt sky130_fd_sc_hd__clkbuf_16 A VGND VNB VPB VPWR X
.ends

* Black-box entry subcircuit for sky130_fd_sc_hd__and4_1 abstract view
.subckt sky130_fd_sc_hd__and4_1 A B C D VGND VNB VPB VPWR X
.ends

* Black-box entry subcircuit for sky130_fd_sc_hd__a211o_1 abstract view
.subckt sky130_fd_sc_hd__a211o_1 A1 A2 B1 C1 VGND VNB VPB VPWR X
.ends

* Black-box entry subcircuit for sky130_fd_sc_hd__a31oi_2 abstract view
.subckt sky130_fd_sc_hd__a31oi_2 A1 A2 A3 B1 VGND VNB VPB VPWR Y
.ends

* Black-box entry subcircuit for sky130_fd_sc_hd__o31a_1 abstract view
.subckt sky130_fd_sc_hd__o31a_1 A1 A2 A3 B1 VGND VNB VPB VPWR X
.ends

* Black-box entry subcircuit for sky130_fd_sc_hd__o211a_1 abstract view
.subckt sky130_fd_sc_hd__o211a_1 A1 A2 B1 C1 VGND VNB VPB VPWR X
.ends

* Black-box entry subcircuit for sky130_fd_sc_hd__clkbuf_2 abstract view
.subckt sky130_fd_sc_hd__clkbuf_2 A VGND VNB VPB VPWR X
.ends

* Black-box entry subcircuit for sky130_fd_sc_hd__a211oi_1 abstract view
.subckt sky130_fd_sc_hd__a211oi_1 A1 A2 B1 C1 VGND VNB VPB VPWR Y
.ends

* Black-box entry subcircuit for sky130_fd_sc_hd__a21boi_1 abstract view
.subckt sky130_fd_sc_hd__a21boi_1 A1 A2 B1_N VGND VNB VPB VPWR Y
.ends

* Black-box entry subcircuit for sky130_fd_sc_hd__a2bb2o_1 abstract view
.subckt sky130_fd_sc_hd__a2bb2o_1 A1_N A2_N B1 B2 VGND VNB VPB VPWR X
.ends

* Black-box entry subcircuit for sky130_fd_sc_hd__buf_1 abstract view
.subckt sky130_fd_sc_hd__buf_1 A VGND VNB VPB VPWR X
.ends

* Black-box entry subcircuit for sky130_fd_sc_hd__a21bo_1 abstract view
.subckt sky130_fd_sc_hd__a21bo_1 A1 A2 B1_N VGND VNB VPB VPWR X
.ends

* Black-box entry subcircuit for sky130_fd_sc_hd__o211ai_1 abstract view
.subckt sky130_fd_sc_hd__o211ai_1 A1 A2 B1 C1 VGND VNB VPB VPWR Y
.ends

* Black-box entry subcircuit for sky130_fd_sc_hd__xor2_2 abstract view
.subckt sky130_fd_sc_hd__xor2_2 A B VGND VNB VPB VPWR X
.ends

* Black-box entry subcircuit for sky130_fd_sc_hd__or2_2 abstract view
.subckt sky130_fd_sc_hd__or2_2 A B VGND VNB VPB VPWR X
.ends

* Black-box entry subcircuit for sky130_fd_sc_hd__mux2_1 abstract view
.subckt sky130_fd_sc_hd__mux2_1 A0 A1 S VGND VNB VPB VPWR X
.ends

* Black-box entry subcircuit for sky130_fd_sc_hd__o21bai_1 abstract view
.subckt sky130_fd_sc_hd__o21bai_1 A1 A2 B1_N VGND VNB VPB VPWR Y
.ends

* Black-box entry subcircuit for sky130_fd_sc_hd__nand3b_1 abstract view
.subckt sky130_fd_sc_hd__nand3b_1 A_N B C VGND VNB VPB VPWR Y
.ends

* Black-box entry subcircuit for sky130_fd_sc_hd__conb_1 abstract view
.subckt sky130_fd_sc_hd__conb_1 VGND VNB VPB VPWR HI LO
.ends

* Black-box entry subcircuit for sky130_fd_sc_hd__a31oi_4 abstract view
.subckt sky130_fd_sc_hd__a31oi_4 A1 A2 A3 B1 VGND VNB VPB VPWR Y
.ends

* Black-box entry subcircuit for sky130_fd_sc_hd__a311o_2 abstract view
.subckt sky130_fd_sc_hd__a311o_2 A1 A2 A3 B1 C1 VGND VNB VPB VPWR X
.ends

* Black-box entry subcircuit for sky130_fd_sc_hd__a22oi_1 abstract view
.subckt sky130_fd_sc_hd__a22oi_1 A1 A2 B1 B2 VGND VNB VPB VPWR Y
.ends

* Black-box entry subcircuit for sky130_fd_sc_hd__inv_2 abstract view
.subckt sky130_fd_sc_hd__inv_2 A VGND VNB VPB VPWR Y
.ends

* Black-box entry subcircuit for sky130_fd_sc_hd__o2bb2a_1 abstract view
.subckt sky130_fd_sc_hd__o2bb2a_1 A1_N A2_N B1 B2 VGND VNB VPB VPWR X
.ends

.subckt fir_filter_top VGND VPWR clk data_in[0] data_in[1] data_in[2] data_in[3] data_in[4]
+ data_in[5] data_in[6] data_in[7] data_out[0] data_out[10] data_out[11] data_out[12]
+ data_out[1] data_out[2] data_out[3] data_out[4] data_out[5] data_out[6] data_out[7]
+ data_out[8] data_out[9] reset
XTAP_TAPCELL_ROW_9_126 VGND VPWR sky130_fd_sc_hd__tapvpwrvgnd_1
XFILLER_13_111 VGND VGND VPWR VPWR sky130_fd_sc_hd__fill_1
X_432_ _161_ _195_ VGND VGND VPWR VPWR _196_ sky130_fd_sc_hd__nor2_1
XFILLER_26_41 VGND VGND VPWR VPWR sky130_fd_sc_hd__fill_1
XFILLER_26_52 VGND VGND VPWR VPWR sky130_fd_sc_hd__fill_2
XFILLER_26_85 VGND VGND VPWR VPWR sky130_fd_sc_hd__fill_2
X_501_ _243_ _260_ _261_ VGND VGND VPWR VPWR _263_ sky130_fd_sc_hd__nor3_1
X_363_ _098_ _126_ VGND VGND VPWR VPWR _129_ sky130_fd_sc_hd__nand2_1
XTAP_TAPCELL_ROW_23_183 VGND VPWR sky130_fd_sc_hd__tapvpwrvgnd_1
XPHY_EDGE_ROW_19_Left_61 VGND VGND VPWR VPWR sky130_fd_sc_hd__decap_3
XFILLER_27_225 VPWR VGND VPWR VGND sky130_ef_sc_hd__decap_12
XFILLER_12_65 VPWR VGND VPWR VGND sky130_ef_sc_hd__decap_12
XFILLER_18_214 VGND VGND VPWR VPWR sky130_fd_sc_hd__decap_3
XFILLER_18_236 VGND VGND VPWR VPWR sky130_fd_sc_hd__fill_1
XFILLER_37_51 VGND VGND VPWR VPWR sky130_fd_sc_hd__decap_4
X_346_ _110_ _111_ VGND VGND VPWR VPWR _112_ sky130_fd_sc_hd__xnor2_1
X_415_ symmetric_preadders.add_pair1.gen_fa\[4\].fa.b symmetric_preadders.add_pair1.gen_fa\[4\].fa.a
+ VGND VGND VPWR VPWR _179_ sky130_fd_sc_hd__or2_1
XFILLER_5_162 VGND VGND VPWR VPWR sky130_fd_sc_hd__decap_6
XPHY_EDGE_ROW_4_Left_46 VGND VGND VPWR VPWR sky130_fd_sc_hd__decap_3
XTAP_TAPCELL_ROW_40_248 VGND VPWR sky130_fd_sc_hd__tapvpwrvgnd_1
XFILLER_0_57 VPWR VGND VPWR VGND sky130_ef_sc_hd__decap_12
X_329_ _094_ _095_ VGND VGND VPWR VPWR _096_ sky130_fd_sc_hd__nand2b_1
XTAP_TAPCELL_ROW_31_215 VGND VPWR sky130_fd_sc_hd__tapvpwrvgnd_1
XFILLER_12_209 VPWR VGND VPWR VGND sky130_ef_sc_hd__decap_12
X_680_ coefficient_adder.add_final.gen_fa\[11\].fa.cout VGND VGND VPWR VPWR net12
+ sky130_fd_sc_hd__clkbuf_1
XFILLER_18_53 VGND VGND VPWR VPWR sky130_fd_sc_hd__decap_8
XFILLER_18_97 VGND VGND VPWR VPWR sky130_fd_sc_hd__fill_2
XFILLER_11_220 VGND VGND VPWR VPWR sky130_fd_sc_hd__decap_4
XFILLER_34_41 VPWR VGND VPWR VGND sky130_ef_sc_hd__decap_12
XFILLER_34_85 VGND VGND VPWR VPWR sky130_fd_sc_hd__decap_8
XFILLER_4_227 VPWR VGND VPWR VGND sky130_ef_sc_hd__decap_12
XFILLER_4_205 VGND VGND VPWR VPWR sky130_fd_sc_hd__fill_2
XFILLER_20_65 VGND VGND VPWR VPWR sky130_fd_sc_hd__fill_1
Xhold30 symmetric_preadders.add_pair1.gen_fa\[0\].fa.a VGND VGND VPWR VPWR net58 sky130_fd_sc_hd__dlygate4sd3_1
X_594_ net26 net33 VGND VGND VPWR VPWR _047_ sky130_fd_sc_hd__and2b_1
X_663_ clknet_2_0__leaf_clk _043_ VGND VGND VPWR VPWR symmetric_preadders.add_pair0.gen_fa\[3\].fa.b
+ sky130_fd_sc_hd__dfxtp_1
XFILLER_13_3 VPWR VGND VPWR VGND sky130_ef_sc_hd__decap_12
XFILLER_19_172 VPWR VGND VPWR VGND sky130_ef_sc_hd__decap_12
XFILLER_34_153 VPWR VGND VPWR VGND sky130_ef_sc_hd__decap_12
XFILLER_34_197 VGND VGND VPWR VPWR sky130_fd_sc_hd__fill_2
XFILLER_40_101 VGND VGND VPWR VPWR sky130_fd_sc_hd__decap_3
Xoutput20 net20 VGND VGND VPWR VPWR data_out[8] sky130_fd_sc_hd__buf_2
XPHY_EDGE_ROW_33_Left_75 VGND VGND VPWR VPWR sky130_fd_sc_hd__decap_3
X_646_ clknet_2_0__leaf_clk _026_ VGND VGND VPWR VPWR symmetric_preadders.add_pair1.gen_fa\[2\].fa.a
+ sky130_fd_sc_hd__dfxtp_1
XFILLER_16_197 VGND VGND VPWR VPWR sky130_fd_sc_hd__decap_8
XTAP_TAPCELL_ROW_26_192 VGND VPWR sky130_fd_sc_hd__tapvpwrvgnd_1
X_577_ net26 net45 VGND VGND VPWR VPWR _030_ sky130_fd_sc_hd__and2b_1
XFILLER_31_101 VGND VGND VPWR VPWR sky130_fd_sc_hd__decap_8
XFILLER_31_167 VGND VGND VPWR VPWR sky130_fd_sc_hd__fill_1
XFILLER_39_245 VGND VGND VPWR VPWR sky130_fd_sc_hd__fill_2
XTAP_TAPCELL_ROW_9_127 VGND VPWR sky130_fd_sc_hd__tapvpwrvgnd_1
X_500_ _260_ _261_ _243_ VGND VGND VPWR VPWR _262_ sky130_fd_sc_hd__o21ai_1
X_362_ _098_ _126_ _125_ VGND VGND VPWR VPWR _128_ sky130_fd_sc_hd__o21a_1
X_431_ _098_ _126_ _140_ _160_ _125_ VGND VGND VPWR VPWR _195_ sky130_fd_sc_hd__o221a_1
XFILLER_3_79 VGND VGND VPWR VPWR sky130_fd_sc_hd__fill_2
XFILLER_3_57 VPWR VGND VPWR VGND sky130_ef_sc_hd__decap_12
X_629_ clknet_2_1__leaf_clk _009_ VGND VGND VPWR VPWR symmetric_preadders.add_pair2.gen_fa\[1\].fa.b
+ sky130_fd_sc_hd__dfxtp_1
XFILLER_6_119 VPWR VGND VPWR VGND sky130_ef_sc_hd__decap_12
XFILLER_12_77 VGND VGND VPWR VPWR sky130_fd_sc_hd__decap_6
XFILLER_37_96 VGND VGND VPWR VPWR sky130_fd_sc_hd__decap_4
X_345_ _058_ _085_ _087_ _086_ VGND VGND VPWR VPWR _111_ sky130_fd_sc_hd__a31o_1
X_414_ _176_ _177_ VGND VGND VPWR VPWR _178_ sky130_fd_sc_hd__xor2_1
XTAP_TAPCELL_ROW_11_132 VGND VPWR sky130_fd_sc_hd__tapvpwrvgnd_1
XPHY_EDGE_ROW_20_Left_62 VGND VGND VPWR VPWR sky130_fd_sc_hd__decap_3
XTAP_TAPCELL_ROW_34_224 VGND VPWR sky130_fd_sc_hd__tapvpwrvgnd_1
XPHY_EDGE_ROW_12_Right_12 VGND VGND VPWR VPWR sky130_fd_sc_hd__decap_3
XFILLER_15_207 VPWR VGND VPWR VGND sky130_ef_sc_hd__decap_12
XPHY_EDGE_ROW_21_Right_21 VGND VGND VPWR VPWR sky130_fd_sc_hd__decap_3
XTAP_TAPCELL_ROW_40_249 VGND VPWR sky130_fd_sc_hd__tapvpwrvgnd_1
XFILLER_23_65 VPWR VGND VPWR VGND sky130_ef_sc_hd__decap_12
XPHY_EDGE_ROW_30_Right_30 VGND VGND VPWR VPWR sky130_fd_sc_hd__decap_3
XFILLER_2_166 VGND VGND VPWR VPWR sky130_fd_sc_hd__decap_3
XFILLER_0_69 VPWR VGND VPWR VGND sky130_ef_sc_hd__decap_12
XFILLER_14_240 VGND VGND VPWR VPWR sky130_fd_sc_hd__decap_6
X_328_ _080_ _092_ _093_ VGND VGND VPWR VPWR _095_ sky130_fd_sc_hd__or3_1
XTAP_TAPCELL_ROW_0_90 VGND VPWR sky130_fd_sc_hd__tapvpwrvgnd_1
XFILLER_7_225 VPWR VGND VPWR VGND sky130_ef_sc_hd__decap_12
XFILLER_34_53 VPWR VGND VPWR VGND sky130_ef_sc_hd__decap_12
XFILLER_29_107 VGND VGND VPWR VPWR sky130_fd_sc_hd__decap_4
XFILLER_4_239 VGND VGND VPWR VPWR sky130_fd_sc_hd__decap_8
X_662_ clknet_2_0__leaf_clk _042_ VGND VGND VPWR VPWR symmetric_preadders.add_pair0.gen_fa\[2\].fa.b
+ sky130_fd_sc_hd__dfxtp_1
Xhold20 symmetric_preadders.add_pair1.gen_fa\[2\].fa.a VGND VGND VPWR VPWR net48 sky130_fd_sc_hd__dlygate4sd3_1
Xhold31 symmetric_preadders.add_pair1.gen_fa\[5\].fa.b VGND VGND VPWR VPWR net59 sky130_fd_sc_hd__dlygate4sd3_1
X_593_ net26 net47 VGND VGND VPWR VPWR _046_ sky130_fd_sc_hd__and2b_1
XFILLER_6_79 VGND VGND VPWR VPWR sky130_fd_sc_hd__decap_4
XFILLER_19_184 VGND VGND VPWR VPWR sky130_fd_sc_hd__decap_6
XFILLER_34_165 VPWR VGND VPWR VGND sky130_ef_sc_hd__decap_12
XPHY_EDGE_ROW_6_Right_6 VGND VGND VPWR VPWR sky130_fd_sc_hd__decap_3
Xoutput10 net10 VGND VGND VPWR VPWR data_out[10] sky130_fd_sc_hd__buf_2
Xoutput21 net21 VGND VGND VPWR VPWR data_out[9] sky130_fd_sc_hd__buf_2
X_645_ clknet_2_0__leaf_clk _025_ VGND VGND VPWR VPWR symmetric_preadders.add_pair1.gen_fa\[1\].fa.a
+ sky130_fd_sc_hd__dfxtp_1
XFILLER_16_110 VPWR VGND VPWR VGND sky130_ef_sc_hd__decap_12
X_576_ net26 net39 VGND VGND VPWR VPWR _029_ sky130_fd_sc_hd__and2b_1
XTAP_TAPCELL_ROW_26_193 VGND VPWR sky130_fd_sc_hd__tapvpwrvgnd_1
XFILLER_31_113 VGND VGND VPWR VPWR sky130_fd_sc_hd__fill_1
XFILLER_13_113 VGND VGND VPWR VPWR sky130_fd_sc_hd__fill_1
X_361_ _098_ _126_ _125_ VGND VGND VPWR VPWR _127_ sky130_fd_sc_hd__o21ai_1
X_430_ _192_ _193_ VGND VGND VPWR VPWR _194_ sky130_fd_sc_hd__and2b_1
XFILLER_3_69 VGND VGND VPWR VPWR sky130_fd_sc_hd__fill_2
X_628_ clknet_2_1__leaf_clk _008_ VGND VGND VPWR VPWR symmetric_preadders.add_pair2.gen_fa\[0\].fa.b
+ sky130_fd_sc_hd__dfxtp_1
XFILLER_12_190 VGND VGND VPWR VPWR sky130_fd_sc_hd__decap_6
X_559_ net24 net42 VGND VGND VPWR VPWR _012_ sky130_fd_sc_hd__and2b_1
XFILLER_27_205 VGND VGND VPWR VPWR sky130_fd_sc_hd__fill_1
XFILLER_5_6 VPWR VGND VPWR VGND sky130_ef_sc_hd__decap_12
X_413_ _107_ _142_ _145_ _143_ VGND VGND VPWR VPWR _177_ sky130_fd_sc_hd__a31o_1
XTAP_TAPCELL_ROW_28_200 VGND VPWR sky130_fd_sc_hd__tapvpwrvgnd_1
XTAP_TAPCELL_ROW_11_133 VGND VPWR sky130_fd_sc_hd__tapvpwrvgnd_1
X_344_ _107_ _109_ VGND VGND VPWR VPWR _110_ sky130_fd_sc_hd__nand2_1
XFILLER_5_120 VGND VGND VPWR VPWR sky130_fd_sc_hd__fill_2
XTAP_TAPCELL_ROW_34_225 VGND VPWR sky130_fd_sc_hd__tapvpwrvgnd_1
XFILLER_15_219 VGND VGND VPWR VPWR sky130_fd_sc_hd__decap_4
XFILLER_23_55 VGND VGND VPWR VPWR sky130_fd_sc_hd__fill_1
XFILLER_23_77 VGND VGND VPWR VPWR sky130_fd_sc_hd__decap_8
XFILLER_3_3 VPWR VGND VPWR VGND sky130_ef_sc_hd__decap_12
XFILLER_0_15 VPWR VGND VPWR VGND sky130_ef_sc_hd__decap_12
XFILLER_0_37 VGND VGND VPWR VPWR sky130_fd_sc_hd__fill_1
XFILLER_0_48 VGND VGND VPWR VPWR sky130_fd_sc_hd__decap_8
XFILLER_9_68 VGND VGND VPWR VPWR sky130_fd_sc_hd__fill_1
XFILLER_9_57 VGND VGND VPWR VPWR sky130_fd_sc_hd__decap_3
X_327_ _092_ _093_ _080_ VGND VGND VPWR VPWR _094_ sky130_fd_sc_hd__o21a_1
XTAP_TAPCELL_ROW_0_91 VGND VPWR sky130_fd_sc_hd__tapvpwrvgnd_1
XFILLER_36_3 VPWR VGND VPWR VGND sky130_ef_sc_hd__decap_12
XFILLER_7_237 VGND VGND VPWR VPWR sky130_fd_sc_hd__decap_8
XFILLER_34_65 VPWR VGND VPWR VGND sky130_ef_sc_hd__decap_12
Xhold21 symmetric_preadders.add_pair0.gen_fa\[2\].fa.a VGND VGND VPWR VPWR net49 sky130_fd_sc_hd__dlygate4sd3_1
X_661_ clknet_2_0__leaf_clk _041_ VGND VGND VPWR VPWR symmetric_preadders.add_pair0.gen_fa\[1\].fa.b
+ sky130_fd_sc_hd__dfxtp_1
Xhold32 symmetric_preadders.add_pair1.gen_fa\[2\].fa.b VGND VGND VPWR VPWR net60 sky130_fd_sc_hd__dlygate4sd3_1
Xhold10 symmetric_preadders.add_pair0.gen_fa\[3\].fa.a VGND VGND VPWR VPWR net38 sky130_fd_sc_hd__dlygate4sd3_1
X_592_ net26 net59 VGND VGND VPWR VPWR _045_ sky130_fd_sc_hd__and2b_1
XFILLER_28_141 VPWR VGND VPWR VGND sky130_ef_sc_hd__decap_12
XFILLER_34_100 VPWR VGND VPWR VGND sky130_ef_sc_hd__decap_12
XFILLER_34_177 VPWR VGND VPWR VGND sky130_ef_sc_hd__decap_12
XFILLER_25_111 VGND VGND VPWR VPWR sky130_fd_sc_hd__fill_1
XFILLER_25_166 VGND VGND VPWR VPWR sky130_fd_sc_hd__fill_2
Xoutput11 net11 VGND VGND VPWR VPWR data_out[11] sky130_fd_sc_hd__buf_2
X_644_ clknet_2_0__leaf_clk _024_ VGND VGND VPWR VPWR symmetric_preadders.add_pair1.gen_fa\[0\].fa.a
+ sky130_fd_sc_hd__dfxtp_1
XFILLER_16_122 VPWR VGND VPWR VGND sky130_ef_sc_hd__decap_12
X_575_ net22 net40 VGND VGND VPWR VPWR _028_ sky130_fd_sc_hd__and2b_1
XTAP_TAPCELL_ROW_26_194 VGND VPWR sky130_fd_sc_hd__tapvpwrvgnd_1
XFILLER_31_169 VGND VGND VPWR VPWR sky130_fd_sc_hd__decap_4
XFILLER_39_225 VPWR VGND VPWR VGND sky130_ef_sc_hd__decap_12
XFILLER_9_129 VGND VGND VPWR VPWR sky130_fd_sc_hd__fill_1
XFILLER_13_103 VGND VGND VPWR VPWR sky130_fd_sc_hd__decap_8
XFILLER_13_169 VPWR VGND VPWR VGND sky130_ef_sc_hd__decap_12
X_360_ _106_ _124_ VGND VGND VPWR VPWR _126_ sky130_fd_sc_hd__nor2_1
XFILLER_3_15 VPWR VGND VPWR VGND sky130_ef_sc_hd__decap_12
XFILLER_36_206 VPWR VGND VPWR VGND sky130_ef_sc_hd__decap_12
X_627_ clknet_2_3__leaf_clk _007_ VGND VGND VPWR VPWR symmetric_preadders.add_pair1.gen_fa\[7\].fa.b
+ sky130_fd_sc_hd__dfxtp_1
X_558_ net24 net37 VGND VGND VPWR VPWR _011_ sky130_fd_sc_hd__and2b_1
XFILLER_8_195 VGND VGND VPWR VPWR sky130_fd_sc_hd__fill_1
X_489_ symmetric_preadders.add_pair0.gen_fa\[7\].fa.b symmetric_preadders.add_pair0.gen_fa\[7\].fa.a
+ VGND VGND VPWR VPWR _251_ sky130_fd_sc_hd__or2_1
XFILLER_10_117 VGND VGND VPWR VPWR sky130_fd_sc_hd__decap_6
XFILLER_10_128 VPWR VGND VPWR VGND sky130_ef_sc_hd__decap_12
XTAP_TAPCELL_ROW_5_110 VGND VPWR sky130_fd_sc_hd__tapvpwrvgnd_1
X_412_ _173_ _175_ VGND VGND VPWR VPWR _176_ sky130_fd_sc_hd__nand2_1
XTAP_TAPCELL_ROW_28_201 VGND VPWR sky130_fd_sc_hd__tapvpwrvgnd_1
XTAP_TAPCELL_ROW_11_134 VGND VPWR sky130_fd_sc_hd__tapvpwrvgnd_1
X_343_ symmetric_preadders.add_pair0.gen_fa\[3\].fa.b symmetric_preadders.add_pair0.gen_fa\[3\].fa.a
+ VGND VGND VPWR VPWR _109_ sky130_fd_sc_hd__nand2_1
XFILLER_24_209 VPWR VGND VPWR VGND sky130_ef_sc_hd__decap_12
XTAP_TAPCELL_ROW_34_226 VGND VPWR sky130_fd_sc_hd__tapvpwrvgnd_1
XFILLER_2_113 VPWR VGND VPWR VGND sky130_ef_sc_hd__decap_12
XFILLER_0_27 VGND VGND VPWR VPWR sky130_fd_sc_hd__fill_1
X_326_ _061_ _090_ _091_ VGND VGND VPWR VPWR _093_ sky130_fd_sc_hd__and3_1
XFILLER_29_3 VPWR VGND VPWR VGND sky130_ef_sc_hd__decap_12
XFILLER_34_77 VGND VGND VPWR VPWR sky130_fd_sc_hd__decap_6
XFILLER_11_245 VGND VGND VPWR VPWR sky130_fd_sc_hd__fill_2
X_309_ _063_ _074_ _075_ VGND VGND VPWR VPWR _076_ sky130_fd_sc_hd__nand3_1
XFILLER_37_175 VGND VGND VPWR VPWR sky130_fd_sc_hd__fill_1
XFILLER_20_24 VGND VGND VPWR VPWR sky130_fd_sc_hd__decap_4
Xhold22 symmetric_preadders.add_pair0.gen_fa\[0\].fa.a VGND VGND VPWR VPWR net50 sky130_fd_sc_hd__dlygate4sd3_1
Xhold11 symmetric_preadders.add_pair0.gen_fa\[5\].fa.a VGND VGND VPWR VPWR net39 sky130_fd_sc_hd__dlygate4sd3_1
Xhold33 symmetric_preadders.add_pair2.gen_fa\[1\].fa.b VGND VGND VPWR VPWR net61 sky130_fd_sc_hd__dlygate4sd3_1
X_660_ clknet_2_0__leaf_clk _040_ VGND VGND VPWR VPWR symmetric_preadders.add_pair0.gen_fa\[0\].fa.b
+ sky130_fd_sc_hd__dfxtp_1
X_591_ net25 net55 VGND VGND VPWR VPWR _044_ sky130_fd_sc_hd__and2b_1
XFILLER_28_153 VPWR VGND VPWR VGND sky130_ef_sc_hd__decap_12
XFILLER_28_197 VPWR VGND VPWR VGND sky130_ef_sc_hd__decap_12
XFILLER_6_59 VGND VGND VPWR VPWR sky130_fd_sc_hd__fill_1
XFILLER_6_15 VPWR VGND VPWR VGND sky130_ef_sc_hd__decap_12
XFILLER_34_112 VPWR VGND VPWR VGND sky130_ef_sc_hd__decap_12
XFILLER_34_189 VGND VGND VPWR VPWR sky130_fd_sc_hd__decap_6
XFILLER_40_148 VPWR VGND VPWR VGND sky130_ef_sc_hd__decap_12
XFILLER_40_137 VGND VGND VPWR VPWR sky130_fd_sc_hd__decap_3
XFILLER_25_156 VGND VGND VPWR VPWR sky130_fd_sc_hd__decap_4
Xoutput12 net12 VGND VGND VPWR VPWR data_out[12] sky130_fd_sc_hd__buf_2
X_643_ clknet_2_3__leaf_clk _023_ VGND VGND VPWR VPWR symmetric_preadders.add_pair2.gen_fa\[7\].fa.a
+ sky130_fd_sc_hd__dfxtp_1
X_574_ net22 net38 VGND VGND VPWR VPWR _027_ sky130_fd_sc_hd__and2b_1
XFILLER_16_134 VGND VGND VPWR VPWR sky130_fd_sc_hd__decap_6
XTAP_TAPCELL_ROW_26_195 VGND VPWR sky130_fd_sc_hd__tapvpwrvgnd_1
XFILLER_39_237 VGND VGND VPWR VPWR sky130_fd_sc_hd__decap_8
XFILLER_11_3 VPWR VGND VPWR VGND sky130_ef_sc_hd__decap_12
XPHY_EDGE_ROW_37_Left_79 VGND VGND VPWR VPWR sky130_fd_sc_hd__decap_3
XFILLER_13_126 VPWR VGND VPWR VGND sky130_ef_sc_hd__decap_12
XFILLER_3_27 VPWR VGND VPWR VGND sky130_ef_sc_hd__decap_12
XFILLER_36_218 VPWR VGND VPWR VGND sky130_ef_sc_hd__decap_12
X_557_ net23 net62 VGND VGND VPWR VPWR _010_ sky130_fd_sc_hd__and2b_1
X_488_ _247_ _249_ VGND VGND VPWR VPWR _250_ sky130_fd_sc_hd__xnor2_1
X_626_ clknet_2_2__leaf_clk _006_ VGND VGND VPWR VPWR symmetric_preadders.add_pair1.gen_fa\[6\].fa.b
+ sky130_fd_sc_hd__dfxtp_1
XFILLER_8_141 VPWR VGND VPWR VGND sky130_ef_sc_hd__decap_12
XTAP_TAPCELL_ROW_20_168 VGND VPWR sky130_fd_sc_hd__tapvpwrvgnd_1
XTAP_TAPCELL_ROW_5_111 VGND VPWR sky130_fd_sc_hd__tapvpwrvgnd_1
XTAP_TAPCELL_ROW_28_202 VGND VPWR sky130_fd_sc_hd__tapvpwrvgnd_1
XFILLER_37_55 VGND VGND VPWR VPWR sky130_fd_sc_hd__fill_1
X_342_ symmetric_preadders.add_pair0.gen_fa\[3\].fa.b symmetric_preadders.add_pair0.gen_fa\[3\].fa.a
+ VGND VGND VPWR VPWR _108_ sky130_fd_sc_hd__and2_1
X_411_ symmetric_preadders.add_pair0.gen_fa\[5\].fa.b symmetric_preadders.add_pair0.gen_fa\[5\].fa.a
+ VGND VGND VPWR VPWR _175_ sky130_fd_sc_hd__nand2_1
XFILLER_26_240 VGND VGND VPWR VPWR sky130_fd_sc_hd__decap_6
XTAP_TAPCELL_ROW_11_135 VGND VPWR sky130_fd_sc_hd__tapvpwrvgnd_1
X_609_ _057_ _060_ VGND VGND VPWR VPWR _061_ sky130_fd_sc_hd__or2_1
XFILLER_32_221 VPWR VGND VPWR VGND sky130_ef_sc_hd__decap_12
XTAP_TAPCELL_ROW_34_227 VGND VPWR sky130_fd_sc_hd__tapvpwrvgnd_1
XFILLER_23_221 VGND VGND VPWR VPWR sky130_fd_sc_hd__decap_3
XFILLER_23_57 VGND VGND VPWR VPWR sky130_fd_sc_hd__fill_1
XFILLER_2_158 VGND VGND VPWR VPWR sky130_fd_sc_hd__decap_8
XFILLER_2_125 VPWR VGND VPWR VGND sky130_ef_sc_hd__decap_12
XFILLER_9_48 VGND VGND VPWR VPWR sky130_fd_sc_hd__decap_8
XFILLER_9_15 VGND VGND VPWR VPWR sky130_fd_sc_hd__decap_6
X_325_ _090_ _091_ _061_ VGND VGND VPWR VPWR _092_ sky130_fd_sc_hd__a21oi_1
XPHY_EDGE_ROW_24_Left_66 VGND VGND VPWR VPWR sky130_fd_sc_hd__decap_3
XFILLER_20_246 VGND VGND VPWR VPWR sky130_fd_sc_hd__fill_1
Xclkload0 clknet_2_2__leaf_clk VGND VGND VPWR VPWR clkload0/Y sky130_fd_sc_hd__clkinv_2
X_308_ symmetric_preadders.add_pair2.gen_fa\[0\].fa.b symmetric_preadders.add_pair2.gen_fa\[0\].fa.a
+ symmetric_preadders.add_pair2.gen_fa\[1\].fa.b symmetric_preadders.add_pair2.gen_fa\[1\].fa.a
+ VGND VGND VPWR VPWR _075_ sky130_fd_sc_hd__a22o_1
XFILLER_41_3 VPWR VGND VPWR VGND sky130_ef_sc_hd__decap_12
Xhold34 symmetric_preadders.add_pair2.gen_fa\[2\].fa.a VGND VGND VPWR VPWR net62 sky130_fd_sc_hd__dlygate4sd3_1
Xhold12 symmetric_preadders.add_pair0.gen_fa\[4\].fa.a VGND VGND VPWR VPWR net40 sky130_fd_sc_hd__dlygate4sd3_1
Xhold23 symmetric_preadders.add_pair1.gen_fa\[6\].fa.a VGND VGND VPWR VPWR net51 sky130_fd_sc_hd__dlygate4sd3_1
X_590_ net25 net57 VGND VGND VPWR VPWR _043_ sky130_fd_sc_hd__and2b_1
XFILLER_28_165 VGND VGND VPWR VPWR sky130_fd_sc_hd__fill_1
XFILLER_28_176 VGND VGND VPWR VPWR sky130_fd_sc_hd__fill_1
XFILLER_6_27 VGND VGND VPWR VPWR sky130_fd_sc_hd__fill_1
XFILLER_34_124 VPWR VGND VPWR VGND sky130_ef_sc_hd__decap_12
XPHY_EDGE_ROW_11_Left_53 VGND VGND VPWR VPWR sky130_fd_sc_hd__decap_3
XFILLER_25_113 VPWR VGND VPWR VGND sky130_ef_sc_hd__decap_12
Xoutput13 net13 VGND VGND VPWR VPWR data_out[1] sky130_fd_sc_hd__buf_2
XFILLER_0_223 VGND VGND VPWR VPWR sky130_fd_sc_hd__fill_1
XFILLER_0_245 VGND VGND VPWR VPWR sky130_fd_sc_hd__fill_2
X_642_ clknet_2_3__leaf_clk _022_ VGND VGND VPWR VPWR symmetric_preadders.add_pair2.gen_fa\[6\].fa.a
+ sky130_fd_sc_hd__dfxtp_1
X_573_ net22 net49 VGND VGND VPWR VPWR _026_ sky130_fd_sc_hd__and2b_1
XPHY_EDGE_ROW_19_Right_19 VGND VGND VPWR VPWR sky130_fd_sc_hd__decap_3
XFILLER_21_90 VGND VGND VPWR VPWR sky130_fd_sc_hd__fill_1
XPHY_EDGE_ROW_28_Right_28 VGND VGND VPWR VPWR sky130_fd_sc_hd__decap_3
XPHY_EDGE_ROW_37_Right_37 VGND VGND VPWR VPWR sky130_fd_sc_hd__decap_3
XFILLER_22_116 VGND VGND VPWR VPWR sky130_fd_sc_hd__decap_4
XFILLER_22_127 VPWR VGND VPWR VGND sky130_ef_sc_hd__decap_12
XFILLER_7_81 VPWR VGND VPWR VGND sky130_ef_sc_hd__decap_12
XFILLER_13_138 VPWR VGND VPWR VGND sky130_ef_sc_hd__decap_12
XFILLER_26_57 VGND VGND VPWR VPWR sky130_fd_sc_hd__fill_1
XFILLER_26_79 VGND VGND VPWR VPWR sky130_fd_sc_hd__decap_4
XTAP_TAPCELL_ROW_8_120 VGND VPWR sky130_fd_sc_hd__tapvpwrvgnd_1
XFILLER_3_39 VPWR VGND VPWR VGND sky130_ef_sc_hd__decap_12
X_625_ clknet_2_3__leaf_clk _005_ VGND VGND VPWR VPWR symmetric_preadders.add_pair1.gen_fa\[5\].fa.b
+ sky130_fd_sc_hd__dfxtp_1
XFILLER_8_120 VGND VGND VPWR VPWR sky130_fd_sc_hd__decap_6
X_556_ net23 net63 VGND VGND VPWR VPWR _009_ sky130_fd_sc_hd__and2b_1
XTAP_TAPCELL_ROW_14_144 VGND VPWR sky130_fd_sc_hd__tapvpwrvgnd_1
X_487_ _211_ _248_ VGND VGND VPWR VPWR _249_ sky130_fd_sc_hd__nand2_1
XFILLER_8_197 VGND VGND VPWR VPWR sky130_fd_sc_hd__decap_4
XFILLER_8_153 VPWR VGND VPWR VGND sky130_ef_sc_hd__decap_12
XTAP_TAPCELL_ROW_37_236 VGND VPWR sky130_fd_sc_hd__tapvpwrvgnd_1
XFILLER_12_15 VPWR VGND VPWR VGND sky130_ef_sc_hd__decap_12
XTAP_TAPCELL_ROW_20_169 VGND VPWR sky130_fd_sc_hd__tapvpwrvgnd_1
XTAP_TAPCELL_ROW_28_203 VGND VPWR sky130_fd_sc_hd__tapvpwrvgnd_1
X_341_ symmetric_preadders.add_pair0.gen_fa\[3\].fa.b symmetric_preadders.add_pair0.gen_fa\[3\].fa.a
+ VGND VGND VPWR VPWR _107_ sky130_fd_sc_hd__or2_1
X_410_ symmetric_preadders.add_pair0.gen_fa\[5\].fa.b symmetric_preadders.add_pair0.gen_fa\[5\].fa.a
+ VGND VGND VPWR VPWR _174_ sky130_fd_sc_hd__and2_1
X_608_ _050_ _059_ VGND VGND VPWR VPWR _060_ sky130_fd_sc_hd__xnor2_1
XFILLER_32_233 VPWR VGND VPWR VGND sky130_ef_sc_hd__decap_12
X_539_ _262_ _281_ _285_ _282_ VGND VGND VPWR VPWR _299_ sky130_fd_sc_hd__a31o_1
XFILLER_2_104 VGND VGND VPWR VPWR sky130_fd_sc_hd__fill_1
XFILLER_2_137 VGND VGND VPWR VPWR sky130_fd_sc_hd__decap_3
XFILLER_0_29 VGND VGND VPWR VPWR sky130_fd_sc_hd__decap_8
X_324_ _083_ _088_ _089_ VGND VGND VPWR VPWR _091_ sky130_fd_sc_hd__nand3_1
XFILLER_13_91 VPWR VGND VPWR VGND sky130_ef_sc_hd__decap_12
XFILLER_1_181 VPWR VGND VPWR VGND sky130_ef_sc_hd__decap_12
XPHY_EDGE_ROW_41_Left_83 VGND VGND VPWR VPWR sky130_fd_sc_hd__decap_3
XFILLER_7_207 VPWR VGND VPWR VGND sky130_ef_sc_hd__decap_12
XFILLER_11_225 VPWR VGND VPWR VGND sky130_ef_sc_hd__decap_12
Xclkload1 clknet_2_3__leaf_clk VGND VGND VPWR VPWR clkload1/Y sky130_fd_sc_hd__clkinvlp_4
XFILLER_1_3 VPWR VGND VPWR VGND sky130_ef_sc_hd__decap_12
X_307_ symmetric_preadders.add_pair2.gen_fa\[2\].fa.b symmetric_preadders.add_pair2.gen_fa\[2\].fa.a
+ VGND VGND VPWR VPWR _074_ sky130_fd_sc_hd__xnor2_1
XFILLER_34_3 VPWR VGND VPWR VGND sky130_ef_sc_hd__decap_12
XFILLER_37_111 VGND VGND VPWR VPWR sky130_fd_sc_hd__fill_1
XFILLER_20_15 VGND VGND VPWR VPWR sky130_fd_sc_hd__decap_3
Xhold35 symmetric_preadders.add_pair2.gen_fa\[1\].fa.a VGND VGND VPWR VPWR net63 sky130_fd_sc_hd__dlygate4sd3_1
Xhold24 symmetric_preadders.add_pair1.gen_fa\[3\].fa.a VGND VGND VPWR VPWR net52 sky130_fd_sc_hd__dlygate4sd3_1
Xhold13 symmetric_preadders.add_pair2.gen_fa\[5\].fa.a VGND VGND VPWR VPWR net41 sky130_fd_sc_hd__dlygate4sd3_1
XFILLER_29_57 VGND VGND VPWR VPWR sky130_fd_sc_hd__fill_2
XFILLER_3_221 VGND VGND VPWR VPWR sky130_fd_sc_hd__decap_3
XFILLER_34_136 VGND VGND VPWR VPWR sky130_fd_sc_hd__decap_4
XFILLER_40_117 VPWR VGND VPWR VGND sky130_ef_sc_hd__decap_12
XFILLER_15_15 VGND VGND VPWR VPWR sky130_fd_sc_hd__decap_6
XFILLER_25_125 VPWR VGND VPWR VGND sky130_ef_sc_hd__decap_12
XFILLER_25_169 VPWR VGND VPWR VGND sky130_ef_sc_hd__decap_12
Xoutput14 net14 VGND VGND VPWR VPWR data_out[2] sky130_fd_sc_hd__buf_2
X_572_ net22 net65 VGND VGND VPWR VPWR _025_ sky130_fd_sc_hd__and2b_1
X_641_ clknet_2_3__leaf_clk _021_ VGND VGND VPWR VPWR symmetric_preadders.add_pair2.gen_fa\[5\].fa.a
+ sky130_fd_sc_hd__dfxtp_1
XFILLER_24_180 VPWR VGND VPWR VGND sky130_ef_sc_hd__decap_12
XFILLER_15_191 VGND VGND VPWR VPWR sky130_fd_sc_hd__decap_8
XFILLER_22_139 VGND VGND VPWR VPWR sky130_fd_sc_hd__fill_1
XFILLER_30_183 VPWR VGND VPWR VGND sky130_ef_sc_hd__decap_12
XFILLER_7_93 VPWR VGND VPWR VGND sky130_ef_sc_hd__decap_12
XTAP_TAPCELL_ROW_8_121 VGND VPWR sky130_fd_sc_hd__tapvpwrvgnd_1
X_555_ net23 symmetric_preadders.add_pair2.gen_fa\[0\].fa.a VGND VGND VPWR VPWR _008_
+ sky130_fd_sc_hd__and2b_1
X_624_ clknet_2_3__leaf_clk _004_ VGND VGND VPWR VPWR symmetric_preadders.add_pair1.gen_fa\[4\].fa.b
+ sky130_fd_sc_hd__dfxtp_1
XTAP_TAPCELL_ROW_14_145 VGND VPWR sky130_fd_sc_hd__tapvpwrvgnd_1
XFILLER_16_91 VGND VGND VPWR VPWR sky130_fd_sc_hd__fill_1
X_486_ _148_ _179_ _182_ _212_ _180_ VGND VGND VPWR VPWR _248_ sky130_fd_sc_hd__a311o_1
XFILLER_8_165 VPWR VGND VPWR VGND sky130_ef_sc_hd__decap_12
XTAP_TAPCELL_ROW_37_237 VGND VPWR sky130_fd_sc_hd__tapvpwrvgnd_1
XFILLER_12_27 VGND VGND VPWR VPWR sky130_fd_sc_hd__fill_1
XFILLER_37_57 VPWR VGND VPWR VGND sky130_ef_sc_hd__decap_12
XFILLER_41_245 VGND VGND VPWR VPWR sky130_fd_sc_hd__fill_2
XFILLER_41_223 VGND VGND VPWR VPWR sky130_fd_sc_hd__fill_1
X_340_ _099_ _105_ VGND VGND VPWR VPWR _106_ sky130_fd_sc_hd__xnor2_1
X_538_ _296_ _297_ VGND VGND VPWR VPWR _298_ sky130_fd_sc_hd__nand2b_1
X_607_ symmetric_preadders.add_pair0.gen_fa\[1\].fa.b symmetric_preadders.add_pair0.gen_fa\[1\].fa.a
+ VGND VGND VPWR VPWR _059_ sky130_fd_sc_hd__xnor2_1
XFILLER_32_245 VGND VGND VPWR VPWR sky130_fd_sc_hd__fill_2
X_469_ _230_ _231_ VGND VGND VPWR VPWR _232_ sky130_fd_sc_hd__nand2b_1
XFILLER_4_72 VPWR VGND VPWR VGND sky130_ef_sc_hd__decap_12
XFILLER_23_15 VPWR VGND VPWR VGND sky130_ef_sc_hd__decap_12
XFILLER_23_201 VPWR VGND VPWR VGND sky130_ef_sc_hd__decap_12
XFILLER_23_245 VGND VGND VPWR VPWR sky130_fd_sc_hd__fill_2
XFILLER_2_149 VGND VGND VPWR VPWR sky130_fd_sc_hd__decap_3
X_323_ _088_ _089_ _083_ VGND VGND VPWR VPWR _090_ sky130_fd_sc_hd__a21o_1
XFILLER_9_28 VGND VGND VPWR VPWR sky130_fd_sc_hd__decap_4
XTAP_TAPCELL_ROW_0_84 VGND VPWR sky130_fd_sc_hd__tapvpwrvgnd_1
XFILLER_1_193 VGND VGND VPWR VPWR sky130_fd_sc_hd__decap_3
XTAP_TAPCELL_ROW_30_210 VGND VPWR sky130_fd_sc_hd__tapvpwrvgnd_1
XFILLER_18_15 VPWR VGND VPWR VGND sky130_ef_sc_hd__decap_12
XFILLER_7_219 VGND VGND VPWR VPWR sky130_fd_sc_hd__decap_4
XFILLER_11_237 VGND VGND VPWR VPWR sky130_fd_sc_hd__decap_8
X_306_ symmetric_preadders.add_pair2.gen_fa\[2\].fa.b symmetric_preadders.add_pair2.gen_fa\[2\].fa.a
+ VGND VGND VPWR VPWR _073_ sky130_fd_sc_hd__and2_1
XFILLER_27_3 VPWR VGND VPWR VGND sky130_ef_sc_hd__decap_12
XFILLER_1_84 VGND VGND VPWR VPWR sky130_fd_sc_hd__fill_2
Xhold36 symmetric_preadders.add_pair1.gen_fa\[1\].fa.a VGND VGND VPWR VPWR net64 sky130_fd_sc_hd__dlygate4sd3_1
Xhold25 symmetric_preadders.add_pair1.gen_fa\[0\].fa.b VGND VGND VPWR VPWR net53 sky130_fd_sc_hd__dlygate4sd3_1
Xhold14 symmetric_preadders.add_pair2.gen_fa\[4\].fa.a VGND VGND VPWR VPWR net42 sky130_fd_sc_hd__dlygate4sd3_1
XFILLER_6_29 VPWR VGND VPWR VGND sky130_ef_sc_hd__decap_12
XFILLER_19_101 VGND VGND VPWR VPWR sky130_fd_sc_hd__decap_8
XFILLER_19_156 VPWR VGND VPWR VGND sky130_ef_sc_hd__decap_12
XFILLER_40_129 VGND VGND VPWR VPWR sky130_fd_sc_hd__decap_8
XFILLER_15_27 VPWR VGND VPWR VGND sky130_ef_sc_hd__decap_12
XFILLER_25_137 VGND VGND VPWR VPWR sky130_fd_sc_hd__decap_3
XFILLER_31_15 VGND VGND VPWR VPWR sky130_fd_sc_hd__decap_3
XFILLER_0_203 VPWR VGND VPWR VGND sky130_ef_sc_hd__decap_12
XFILLER_0_225 VPWR VGND VPWR VGND sky130_ef_sc_hd__decap_12
XPHY_EDGE_ROW_1_Right_1 VGND VGND VPWR VPWR sky130_fd_sc_hd__decap_3
Xoutput15 net15 VGND VGND VPWR VPWR data_out[3] sky130_fd_sc_hd__buf_2
X_571_ net22 net50 VGND VGND VPWR VPWR _024_ sky130_fd_sc_hd__and2b_1
X_640_ clknet_2_1__leaf_clk _020_ VGND VGND VPWR VPWR symmetric_preadders.add_pair2.gen_fa\[4\].fa.a
+ sky130_fd_sc_hd__dfxtp_1
XFILLER_24_192 VGND VGND VPWR VPWR sky130_fd_sc_hd__decap_4
XFILLER_30_195 VGND VGND VPWR VPWR sky130_fd_sc_hd__fill_1
XFILLER_26_15 VPWR VGND VPWR VGND sky130_ef_sc_hd__decap_12
XFILLER_21_162 VGND VGND VPWR VPWR sky130_fd_sc_hd__fill_1
XTAP_TAPCELL_ROW_8_122 VGND VPWR sky130_fd_sc_hd__tapvpwrvgnd_1
X_554_ net27 net31 VGND VGND VPWR VPWR _007_ sky130_fd_sc_hd__and2b_1
X_623_ clknet_2_1__leaf_clk _003_ VGND VGND VPWR VPWR symmetric_preadders.add_pair1.gen_fa\[3\].fa.b
+ sky130_fd_sc_hd__dfxtp_1
X_485_ _244_ _246_ VGND VGND VPWR VPWR _247_ sky130_fd_sc_hd__nand2_1
XFILLER_8_177 VPWR VGND VPWR VGND sky130_ef_sc_hd__decap_12
XTAP_TAPCELL_ROW_14_146 VGND VPWR sky130_fd_sc_hd__tapvpwrvgnd_1
XTAP_TAPCELL_ROW_37_238 VGND VPWR sky130_fd_sc_hd__tapvpwrvgnd_1
XFILLER_37_69 VGND VGND VPWR VPWR sky130_fd_sc_hd__decap_3
X_606_ symmetric_preadders.add_pair0.gen_fa\[1\].fa.b symmetric_preadders.add_pair0.gen_fa\[1\].fa.a
+ VGND VGND VPWR VPWR _058_ sky130_fd_sc_hd__or2_1
X_468_ _210_ _229_ VGND VGND VPWR VPWR _231_ sky130_fd_sc_hd__nand2_1
X_537_ _267_ _293_ _294_ _290_ VGND VGND VPWR VPWR _297_ sky130_fd_sc_hd__a31o_1
X_399_ _127_ _163_ VGND VGND VPWR VPWR coefficient_adder.add_final.gen_fa\[5\].fa.sum
+ sky130_fd_sc_hd__xnor2_1
XFILLER_4_191 VGND VGND VPWR VPWR sky130_fd_sc_hd__fill_1
XFILLER_4_62 VGND VGND VPWR VPWR sky130_fd_sc_hd__decap_3
XFILLER_23_213 VGND VGND VPWR VPWR sky130_fd_sc_hd__decap_8
XFILLER_23_27 VPWR VGND VPWR VGND sky130_ef_sc_hd__decap_12
X_322_ _084_ _086_ _087_ _058_ VGND VGND VPWR VPWR _089_ sky130_fd_sc_hd__o211ai_2
XFILLER_14_246 VGND VGND VPWR VPWR sky130_fd_sc_hd__fill_1
XTAP_TAPCELL_ROW_0_85 VGND VPWR sky130_fd_sc_hd__tapvpwrvgnd_1
XFILLER_20_216 VPWR VGND VPWR VGND sky130_ef_sc_hd__decap_12
XTAP_TAPCELL_ROW_30_211 VGND VPWR sky130_fd_sc_hd__tapvpwrvgnd_1
XFILLER_18_27 VGND VGND VPWR VPWR sky130_fd_sc_hd__fill_1
XFILLER_34_15 VPWR VGND VPWR VGND sky130_ef_sc_hd__decap_12
X_305_ symmetric_preadders.add_pair2.gen_fa\[2\].fa.b symmetric_preadders.add_pair2.gen_fa\[2\].fa.a
+ VGND VGND VPWR VPWR _072_ sky130_fd_sc_hd__or2_1
XFILLER_24_81 VGND VGND VPWR VPWR sky130_fd_sc_hd__decap_3
XFILLER_37_113 VPWR VGND VPWR VGND sky130_ef_sc_hd__decap_12
XFILLER_29_15 VPWR VGND VPWR VGND sky130_ef_sc_hd__decap_12
Xhold37 symmetric_preadders.add_pair0.gen_fa\[1\].fa.a VGND VGND VPWR VPWR net65 sky130_fd_sc_hd__dlygate4sd3_1
Xhold15 symmetric_preadders.add_pair2.gen_fa\[4\].fa.b VGND VGND VPWR VPWR net43 sky130_fd_sc_hd__dlygate4sd3_1
XFILLER_28_113 VPWR VGND VPWR VGND sky130_ef_sc_hd__decap_12
Xhold26 symmetric_preadders.add_pair2.gen_fa\[6\].fa.b VGND VGND VPWR VPWR net54 sky130_fd_sc_hd__dlygate4sd3_1
XFILLER_3_245 VGND VGND VPWR VPWR sky130_fd_sc_hd__fill_2
XFILLER_3_201 VPWR VGND VPWR VGND sky130_ef_sc_hd__decap_12
XFILLER_10_61 VGND VGND VPWR VPWR sky130_fd_sc_hd__decap_3
XFILLER_10_83 VGND VGND VPWR VPWR sky130_fd_sc_hd__fill_1
XFILLER_19_113 VGND VGND VPWR VPWR sky130_fd_sc_hd__fill_2
XFILLER_19_146 VGND VGND VPWR VPWR sky130_fd_sc_hd__fill_2
XFILLER_25_105 VGND VGND VPWR VPWR sky130_fd_sc_hd__decap_6
XFILLER_15_39 VGND VGND VPWR VPWR sky130_fd_sc_hd__fill_1
XFILLER_0_215 VGND VGND VPWR VPWR sky130_fd_sc_hd__decap_8
XFILLER_0_237 VGND VGND VPWR VPWR sky130_fd_sc_hd__decap_8
Xoutput16 net16 VGND VGND VPWR VPWR data_out[4] sky130_fd_sc_hd__buf_2
X_570_ net27 net30 VGND VGND VPWR VPWR _023_ sky130_fd_sc_hd__and2b_1
XFILLER_16_149 VGND VGND VPWR VPWR sky130_fd_sc_hd__decap_3
XFILLER_39_208 VPWR VGND VPWR VGND sky130_ef_sc_hd__decap_12
Xclkbuf_0_clk clk VGND VGND VPWR VPWR clknet_0_clk sky130_fd_sc_hd__clkbuf_16
XFILLER_7_51 VGND VGND VPWR VPWR sky130_fd_sc_hd__decap_4
XPHY_EDGE_ROW_15_Left_57 VGND VGND VPWR VPWR sky130_fd_sc_hd__decap_3
XFILLER_30_141 VGND VGND VPWR VPWR sky130_fd_sc_hd__decap_8
XPHY_EDGE_ROW_15_Right_15 VGND VGND VPWR VPWR sky130_fd_sc_hd__decap_3
XPHY_EDGE_ROW_24_Right_24 VGND VGND VPWR VPWR sky130_fd_sc_hd__decap_3
XFILLER_26_27 VGND VGND VPWR VPWR sky130_fd_sc_hd__fill_1
XTAP_TAPCELL_ROW_8_123 VGND VPWR sky130_fd_sc_hd__tapvpwrvgnd_1
XPHY_EDGE_ROW_33_Right_33 VGND VGND VPWR VPWR sky130_fd_sc_hd__decap_3
X_622_ clknet_2_1__leaf_clk _002_ VGND VGND VPWR VPWR symmetric_preadders.add_pair1.gen_fa\[2\].fa.b
+ sky130_fd_sc_hd__dfxtp_1
XFILLER_16_60 VPWR VGND VPWR VGND sky130_ef_sc_hd__decap_12
X_484_ symmetric_preadders.add_pair1.gen_fa\[6\].fa.b symmetric_preadders.add_pair1.gen_fa\[6\].fa.a
+ VGND VGND VPWR VPWR _246_ sky130_fd_sc_hd__nand2_1
X_553_ net27 net54 VGND VGND VPWR VPWR _006_ sky130_fd_sc_hd__and2b_1
XFILLER_8_189 VGND VGND VPWR VPWR sky130_fd_sc_hd__decap_6
XFILLER_12_141 VPWR VGND VPWR VGND sky130_ef_sc_hd__decap_12
XTAP_TAPCELL_ROW_14_147 VGND VPWR sky130_fd_sc_hd__tapvpwrvgnd_1
XFILLER_35_233 VGND VGND VPWR VPWR sky130_fd_sc_hd__fill_1
XTAP_TAPCELL_ROW_37_239 VGND VPWR sky130_fd_sc_hd__tapvpwrvgnd_1
XFILLER_12_29 VPWR VGND VPWR VGND sky130_ef_sc_hd__decap_12
XFILLER_37_15 VPWR VGND VPWR VGND sky130_ef_sc_hd__decap_12
XFILLER_41_225 VPWR VGND VPWR VGND sky130_ef_sc_hd__decap_12
XFILLER_41_203 VPWR VGND VPWR VGND sky130_ef_sc_hd__decap_12
XFILLER_5_137 VGND VGND VPWR VPWR sky130_fd_sc_hd__decap_3
X_605_ _055_ _056_ VGND VGND VPWR VPWR _057_ sky130_fd_sc_hd__nand2_1
XFILLER_27_81 VGND VGND VPWR VPWR sky130_fd_sc_hd__fill_1
X_398_ _161_ _162_ VGND VGND VPWR VPWR _163_ sky130_fd_sc_hd__nor2_1
X_467_ _210_ _229_ VGND VGND VPWR VPWR _230_ sky130_fd_sc_hd__nor2_1
X_536_ _267_ _290_ _293_ _294_ VGND VGND VPWR VPWR _296_ sky130_fd_sc_hd__and4_1
XFILLER_4_85 VPWR VGND VPWR VGND sky130_ef_sc_hd__decap_12
XFILLER_23_225 VPWR VGND VPWR VGND sky130_ef_sc_hd__decap_12
XTAP_TAPCELL_ROW_33_220 VGND VPWR sky130_fd_sc_hd__tapvpwrvgnd_1
XFILLER_23_39 VPWR VGND VPWR VGND sky130_ef_sc_hd__decap_12
XPHY_EDGE_ROW_18_Left_60 VGND VGND VPWR VPWR sky130_fd_sc_hd__decap_3
X_321_ _058_ _087_ _086_ _084_ VGND VGND VPWR VPWR _088_ sky130_fd_sc_hd__a211o_1
XTAP_TAPCELL_ROW_0_86 VGND VPWR sky130_fd_sc_hd__tapvpwrvgnd_1
XFILLER_1_151 VGND VGND VPWR VPWR sky130_fd_sc_hd__fill_1
XFILLER_20_228 VPWR VGND VPWR VGND sky130_ef_sc_hd__decap_12
X_519_ _278_ _279_ VGND VGND VPWR VPWR _280_ sky130_fd_sc_hd__xnor2_1
XFILLER_34_27 VGND VGND VPWR VPWR sky130_fd_sc_hd__fill_1
XPHY_EDGE_ROW_3_Left_45 VGND VGND VPWR VPWR sky130_fd_sc_hd__decap_3
X_304_ _053_ _071_ VGND VGND VPWR VPWR coefficient_adder.add_final.gen_fa\[2\].fa.sum
+ sky130_fd_sc_hd__xnor2_1
XFILLER_6_221 VPWR VGND VPWR VGND sky130_ef_sc_hd__decap_12
XFILLER_37_125 VPWR VGND VPWR VGND sky130_ef_sc_hd__decap_12
XFILLER_20_29 VGND VGND VPWR VPWR sky130_fd_sc_hd__decap_6
Xhold38 symmetric_preadders.add_pair1.gen_fa\[1\].fa.b VGND VGND VPWR VPWR net66 sky130_fd_sc_hd__dlygate4sd3_1
Xhold27 symmetric_preadders.add_pair1.gen_fa\[4\].fa.b VGND VGND VPWR VPWR net55 sky130_fd_sc_hd__dlygate4sd3_1
Xhold16 symmetric_preadders.add_pair1.gen_fa\[5\].fa.a VGND VGND VPWR VPWR net44 sky130_fd_sc_hd__dlygate4sd3_1
XFILLER_29_27 VPWR VGND VPWR VGND sky130_ef_sc_hd__decap_12
XFILLER_28_103 VGND VGND VPWR VPWR sky130_fd_sc_hd__fill_1
XFILLER_28_125 VPWR VGND VPWR VGND sky130_ef_sc_hd__decap_12
XFILLER_3_213 VGND VGND VPWR VPWR sky130_fd_sc_hd__decap_8
XFILLER_35_81 VPWR VGND VPWR VGND sky130_ef_sc_hd__decap_12
Xoutput17 net17 VGND VGND VPWR VPWR data_out[5] sky130_fd_sc_hd__buf_2
XFILLER_31_109 VGND VGND VPWR VPWR sky130_fd_sc_hd__decap_3
XFILLER_21_72 VGND VGND VPWR VPWR sky130_fd_sc_hd__decap_4
XFILLER_15_172 VGND VGND VPWR VPWR sky130_fd_sc_hd__fill_1
XFILLER_15_183 VGND VGND VPWR VPWR sky130_fd_sc_hd__decap_4
XTAP_TAPCELL_ROW_17_156 VGND VPWR sky130_fd_sc_hd__tapvpwrvgnd_1
XFILLER_30_197 VGND VGND VPWR VPWR sky130_fd_sc_hd__decap_4
X_621_ clknet_2_1__leaf_clk _001_ VGND VGND VPWR VPWR symmetric_preadders.add_pair1.gen_fa\[1\].fa.b
+ sky130_fd_sc_hd__dfxtp_1
XFILLER_12_153 VPWR VGND VPWR VGND sky130_ef_sc_hd__decap_12
XFILLER_16_50 VGND VGND VPWR VPWR sky130_fd_sc_hd__decap_6
XFILLER_16_72 VPWR VGND VPWR VGND sky130_ef_sc_hd__decap_12
X_552_ net27 net36 VGND VGND VPWR VPWR _005_ sky130_fd_sc_hd__and2b_1
X_483_ symmetric_preadders.add_pair1.gen_fa\[6\].fa.b symmetric_preadders.add_pair1.gen_fa\[6\].fa.a
+ VGND VGND VPWR VPWR _245_ sky130_fd_sc_hd__and2_1
XPHY_EDGE_ROW_32_Left_74 VGND VGND VPWR VPWR sky130_fd_sc_hd__decap_3
XFILLER_12_197 VPWR VGND VPWR VGND sky130_ef_sc_hd__decap_12
XFILLER_35_245 VGND VGND VPWR VPWR sky130_fd_sc_hd__fill_2
XFILLER_37_27 VPWR VGND VPWR VGND sky130_ef_sc_hd__decap_12
XFILLER_41_237 VGND VGND VPWR VPWR sky130_fd_sc_hd__decap_8
XFILLER_41_215 VGND VGND VPWR VPWR sky130_fd_sc_hd__decap_8
X_604_ symmetric_preadders.add_pair1.gen_fa\[0\].fa.b symmetric_preadders.add_pair1.gen_fa\[0\].fa.a
+ VGND VGND VPWR VPWR _056_ sky130_fd_sc_hd__or2_1
Xclkbuf_2_0__f_clk clknet_0_clk VGND VGND VPWR VPWR clknet_2_0__leaf_clk sky130_fd_sc_hd__clkbuf_16
XFILLER_17_223 VGND VGND VPWR VPWR sky130_fd_sc_hd__fill_1
XFILLER_17_245 VGND VGND VPWR VPWR sky130_fd_sc_hd__fill_2
X_535_ _235_ _237_ _294_ VGND VGND VPWR VPWR _295_ sky130_fd_sc_hd__o21a_1
X_397_ _140_ _160_ VGND VGND VPWR VPWR _162_ sky130_fd_sc_hd__nor2_1
X_466_ _227_ _228_ VGND VGND VPWR VPWR _229_ sky130_fd_sc_hd__xnor2_1
XFILLER_4_97 VGND VGND VPWR VPWR sky130_fd_sc_hd__decap_4
XFILLER_23_237 VGND VGND VPWR VPWR sky130_fd_sc_hd__decap_8
XTAP_TAPCELL_ROW_33_221 VGND VPWR sky130_fd_sc_hd__tapvpwrvgnd_1
XFILLER_14_204 VPWR VGND VPWR VGND sky130_ef_sc_hd__decap_12
X_320_ symmetric_preadders.add_pair0.gen_fa\[0\].fa.b symmetric_preadders.add_pair0.gen_fa\[0\].fa.a
+ symmetric_preadders.add_pair0.gen_fa\[1\].fa.b symmetric_preadders.add_pair0.gen_fa\[1\].fa.a
+ VGND VGND VPWR VPWR _087_ sky130_fd_sc_hd__a22o_1
XFILLER_13_51 VGND VGND VPWR VPWR sky130_fd_sc_hd__decap_4
XFILLER_38_81 VGND VGND VPWR VPWR sky130_fd_sc_hd__decap_3
XTAP_TAPCELL_ROW_0_87 VGND VPWR sky130_fd_sc_hd__tapvpwrvgnd_1
X_518_ _225_ _256_ _259_ _257_ VGND VGND VPWR VPWR _279_ sky130_fd_sc_hd__a31oi_2
X_449_ symmetric_preadders.add_pair1.gen_fa\[5\].fa.b symmetric_preadders.add_pair1.gen_fa\[5\].fa.a
+ VGND VGND VPWR VPWR _212_ sky130_fd_sc_hd__and2_1
XFILLER_18_29 VPWR VGND VPWR VGND sky130_ef_sc_hd__decap_12
XFILLER_6_233 VPWR VGND VPWR VGND sky130_ef_sc_hd__decap_12
XFILLER_24_61 VPWR VGND VPWR VGND sky130_ef_sc_hd__decap_12
XFILLER_37_137 VGND VGND VPWR VPWR sky130_fd_sc_hd__fill_2
Xhold28 symmetric_preadders.add_pair2.gen_fa\[2\].fa.b VGND VGND VPWR VPWR net56 sky130_fd_sc_hd__dlygate4sd3_1
XFILLER_29_39 VPWR VGND VPWR VGND sky130_ef_sc_hd__decap_12
Xhold17 symmetric_preadders.add_pair0.gen_fa\[6\].fa.a VGND VGND VPWR VPWR net45 sky130_fd_sc_hd__dlygate4sd3_1
XFILLER_28_137 VGND VGND VPWR VPWR sky130_fd_sc_hd__decap_3
XFILLER_3_225 VPWR VGND VPWR VGND sky130_ef_sc_hd__decap_12
XFILLER_10_41 VGND VGND VPWR VPWR sky130_fd_sc_hd__decap_4
XFILLER_35_93 VPWR VGND VPWR VGND sky130_ef_sc_hd__decap_12
Xoutput18 net18 VGND VGND VPWR VPWR data_out[6] sky130_fd_sc_hd__buf_2
XTAP_TAPCELL_ROW_17_157 VGND VPWR sky130_fd_sc_hd__tapvpwrvgnd_1
XTAP_TAPCELL_ROW_25_190 VGND VPWR sky130_fd_sc_hd__tapvpwrvgnd_1
XFILLER_38_221 VPWR VGND VPWR VGND sky130_ef_sc_hd__decap_12
XPHY_EDGE_ROW_5_Right_5 VGND VGND VPWR VPWR sky130_fd_sc_hd__decap_3
XFILLER_26_29 VPWR VGND VPWR VGND sky130_ef_sc_hd__decap_12
XFILLER_21_176 VPWR VGND VPWR VGND sky130_ef_sc_hd__decap_12
X_620_ clknet_2_1__leaf_clk _000_ VGND VGND VPWR VPWR symmetric_preadders.add_pair1.gen_fa\[0\].fa.b
+ sky130_fd_sc_hd__dfxtp_1
X_551_ net26 net43 VGND VGND VPWR VPWR _004_ sky130_fd_sc_hd__and2b_1
XFILLER_8_136 VGND VGND VPWR VPWR sky130_fd_sc_hd__decap_4
XFILLER_12_165 VGND VGND VPWR VPWR sky130_fd_sc_hd__decap_4
X_482_ symmetric_preadders.add_pair1.gen_fa\[6\].fa.b symmetric_preadders.add_pair1.gen_fa\[6\].fa.a
+ VGND VGND VPWR VPWR _244_ sky130_fd_sc_hd__or2_1
XFILLER_26_246 VGND VGND VPWR VPWR sky130_fd_sc_hd__fill_1
XFILLER_37_39 VPWR VGND VPWR VGND sky130_ef_sc_hd__decap_12
X_603_ symmetric_preadders.add_pair1.gen_fa\[0\].fa.b symmetric_preadders.add_pair1.gen_fa\[0\].fa.a
+ VGND VGND VPWR VPWR _055_ sky130_fd_sc_hd__nand2_1
X_465_ _187_ _190_ _186_ VGND VGND VPWR VPWR _228_ sky130_fd_sc_hd__o21ai_1
X_534_ _268_ _292_ VGND VGND VPWR VPWR _294_ sky130_fd_sc_hd__or2_1
XTAP_TAPCELL_ROW_10_130 VGND VPWR sky130_fd_sc_hd__tapvpwrvgnd_1
X_396_ _140_ _160_ VGND VGND VPWR VPWR _161_ sky130_fd_sc_hd__and2_1
XFILLER_4_43 VGND VGND VPWR VPWR sky130_fd_sc_hd__decap_3
XTAP_TAPCELL_ROW_33_222 VGND VPWR sky130_fd_sc_hd__tapvpwrvgnd_1
XFILLER_14_216 VPWR VGND VPWR VGND sky130_ef_sc_hd__decap_12
XTAP_TAPCELL_ROW_0_88 VGND VPWR sky130_fd_sc_hd__tapvpwrvgnd_1
X_448_ symmetric_preadders.add_pair1.gen_fa\[5\].fa.b symmetric_preadders.add_pair1.gen_fa\[5\].fa.a
+ VGND VGND VPWR VPWR _211_ sky130_fd_sc_hd__or2_1
X_517_ _276_ _277_ VGND VGND VPWR VPWR _278_ sky130_fd_sc_hd__nand2b_1
X_379_ _141_ _143_ VGND VGND VPWR VPWR _144_ sky130_fd_sc_hd__nor2_1
XFILLER_11_208 VPWR VGND VPWR VGND sky130_ef_sc_hd__decap_12
XFILLER_34_29 VPWR VGND VPWR VGND sky130_ef_sc_hd__decap_12
XFILLER_6_245 VGND VGND VPWR VPWR sky130_fd_sc_hd__fill_2
XFILLER_10_241 VGND VGND VPWR VPWR sky130_fd_sc_hd__fill_2
XFILLER_24_73 VGND VGND VPWR VPWR sky130_fd_sc_hd__decap_8
XFILLER_40_83 VGND VGND VPWR VPWR sky130_fd_sc_hd__fill_1
XFILLER_1_55 VGND VGND VPWR VPWR sky130_fd_sc_hd__fill_1
XFILLER_37_149 VGND VGND VPWR VPWR sky130_fd_sc_hd__decap_3
Xhold29 symmetric_preadders.add_pair1.gen_fa\[3\].fa.b VGND VGND VPWR VPWR net57 sky130_fd_sc_hd__dlygate4sd3_1
Xhold18 symmetric_preadders.add_pair1.gen_fa\[4\].fa.a VGND VGND VPWR VPWR net46 sky130_fd_sc_hd__dlygate4sd3_1
XFILLER_3_237 VGND VGND VPWR VPWR sky130_fd_sc_hd__decap_8
XFILLER_18_3 VPWR VGND VPWR VGND sky130_ef_sc_hd__decap_12
XFILLER_33_130 VPWR VGND VPWR VGND sky130_ef_sc_hd__decap_12
Xoutput19 net19 VGND VGND VPWR VPWR data_out[7] sky130_fd_sc_hd__buf_2
XFILLER_24_141 VPWR VGND VPWR VGND sky130_ef_sc_hd__decap_12
XFILLER_21_30 VGND VGND VPWR VPWR sky130_fd_sc_hd__decap_6
XTAP_TAPCELL_ROW_17_158 VGND VPWR sky130_fd_sc_hd__tapvpwrvgnd_1
XTAP_TAPCELL_ROW_25_191 VGND VPWR sky130_fd_sc_hd__tapvpwrvgnd_1
XFILLER_30_177 VGND VGND VPWR VPWR sky130_fd_sc_hd__decap_3
XFILLER_38_233 VPWR VGND VPWR VGND sky130_ef_sc_hd__decap_12
XFILLER_21_111 VGND VGND VPWR VPWR sky130_fd_sc_hd__fill_1
XFILLER_21_188 VPWR VGND VPWR VGND sky130_ef_sc_hd__decap_12
X_550_ net24 net34 VGND VGND VPWR VPWR _003_ sky130_fd_sc_hd__and2b_1
XFILLER_16_41 VGND VGND VPWR VPWR sky130_fd_sc_hd__decap_3
X_481_ _241_ _242_ VGND VGND VPWR VPWR _243_ sky130_fd_sc_hd__xnor2_1
XFILLER_8_115 VGND VGND VPWR VPWR sky130_fd_sc_hd__fill_1
XPHY_EDGE_ROW_11_Right_11 VGND VGND VPWR VPWR sky130_fd_sc_hd__decap_3
XFILLER_12_111 VPWR VGND VPWR VGND sky130_ef_sc_hd__decap_12
XFILLER_16_85 VGND VGND VPWR VPWR sky130_fd_sc_hd__fill_1
XPHY_EDGE_ROW_20_Right_20 VGND VGND VPWR VPWR sky130_fd_sc_hd__decap_3
X_679_ coefficient_adder.add_final.gen_fa\[11\].fa.sum VGND VGND VPWR VPWR net11 sky130_fd_sc_hd__clkbuf_1
XFILLER_35_225 VGND VGND VPWR VPWR sky130_fd_sc_hd__decap_8
XFILLER_7_181 VGND VGND VPWR VPWR sky130_fd_sc_hd__decap_8
XFILLER_5_129 VGND VGND VPWR VPWR sky130_fd_sc_hd__decap_8
X_602_ _053_ _054_ VGND VGND VPWR VPWR coefficient_adder.add_final.gen_fa\[1\].fa.sum
+ sky130_fd_sc_hd__and2_1
XFILLER_17_225 VPWR VGND VPWR VGND sky130_ef_sc_hd__decap_12
XFILLER_27_51 VGND VGND VPWR VPWR sky130_fd_sc_hd__decap_4
X_464_ _224_ _226_ VGND VGND VPWR VPWR _227_ sky130_fd_sc_hd__nor2_1
X_533_ _268_ _292_ VGND VGND VPWR VPWR _293_ sky130_fd_sc_hd__nand2_1
XTAP_TAPCELL_ROW_10_131 VGND VPWR sky130_fd_sc_hd__tapvpwrvgnd_1
X_395_ _158_ _159_ VGND VGND VPWR VPWR _160_ sky130_fd_sc_hd__nor2_1
XFILLER_4_195 VGND VGND VPWR VPWR sky130_fd_sc_hd__fill_1
XFILLER_4_173 VPWR VGND VPWR VGND sky130_ef_sc_hd__decap_12
XFILLER_4_162 VGND VGND VPWR VPWR sky130_fd_sc_hd__decap_4
XTAP_TAPCELL_ROW_33_223 VGND VPWR sky130_fd_sc_hd__tapvpwrvgnd_1
XFILLER_14_228 VPWR VGND VPWR VGND sky130_ef_sc_hd__decap_12
XFILLER_1_110 VGND VGND VPWR VPWR sky130_fd_sc_hd__fill_2
XTAP_TAPCELL_ROW_0_89 VGND VPWR sky130_fd_sc_hd__tapvpwrvgnd_1
X_378_ symmetric_preadders.add_pair0.gen_fa\[4\].fa.b symmetric_preadders.add_pair0.gen_fa\[4\].fa.a
+ VGND VGND VPWR VPWR _143_ sky130_fd_sc_hd__and2_1
XFILLER_20_209 VGND VGND VPWR VPWR sky130_fd_sc_hd__decap_4
X_447_ _207_ _209_ VGND VGND VPWR VPWR _210_ sky130_fd_sc_hd__xor2_1
X_516_ _252_ _270_ _275_ VGND VGND VPWR VPWR _277_ sky130_fd_sc_hd__nand3_1
XFILLER_39_180 VGND VGND VPWR VPWR sky130_fd_sc_hd__decap_8
XFILLER_24_41 VPWR VGND VPWR VGND sky130_ef_sc_hd__decap_12
XFILLER_24_85 VPWR VGND VPWR VGND sky130_ef_sc_hd__decap_12
Xhold19 symmetric_preadders.add_pair1.gen_fa\[6\].fa.b VGND VGND VPWR VPWR net47 sky130_fd_sc_hd__dlygate4sd3_1
XPHY_EDGE_ROW_7_Left_49 VGND VGND VPWR VPWR sky130_fd_sc_hd__decap_3
XFILLER_36_161 VGND VGND VPWR VPWR sky130_fd_sc_hd__fill_1
XFILLER_19_128 VGND VGND VPWR VPWR sky130_fd_sc_hd__fill_2
XFILLER_35_51 VGND VGND VPWR VPWR sky130_fd_sc_hd__decap_4
XFILLER_32_6 VPWR VGND VPWR VGND sky130_ef_sc_hd__decap_12
XFILLER_24_153 VPWR VGND VPWR VGND sky130_ef_sc_hd__decap_12
XFILLER_24_197 VPWR VGND VPWR VGND sky130_ef_sc_hd__decap_12
XFILLER_21_42 VPWR VGND VPWR VGND sky130_ef_sc_hd__decap_12
XTAP_TAPCELL_ROW_17_159 VGND VPWR sky130_fd_sc_hd__tapvpwrvgnd_1
XFILLER_7_55 VGND VGND VPWR VPWR sky130_fd_sc_hd__fill_1
XFILLER_30_134 VGND VGND VPWR VPWR sky130_fd_sc_hd__decap_6
XFILLER_30_3 VPWR VGND VPWR VGND sky130_ef_sc_hd__decap_12
XFILLER_38_245 VGND VGND VPWR VPWR sky130_fd_sc_hd__fill_2
XFILLER_29_245 VGND VGND VPWR VPWR sky130_fd_sc_hd__fill_2
X_480_ _164_ _205_ _208_ _206_ VGND VGND VPWR VPWR _242_ sky130_fd_sc_hd__o31a_1
XFILLER_12_123 VPWR VGND VPWR VGND sky130_ef_sc_hd__decap_12
XFILLER_12_178 VPWR VGND VPWR VGND sky130_ef_sc_hd__decap_12
XFILLER_32_41 VGND VGND VPWR VPWR sky130_fd_sc_hd__decap_8
XFILLER_35_237 VGND VGND VPWR VPWR sky130_fd_sc_hd__decap_8
X_678_ coefficient_adder.add_final.gen_fa\[10\].fa.sum VGND VGND VPWR VPWR net10 sky130_fd_sc_hd__clkbuf_1
XTAP_TAPCELL_ROW_13_140 VGND VPWR sky130_fd_sc_hd__tapvpwrvgnd_1
XTAP_TAPCELL_ROW_5_108 VGND VPWR sky130_fd_sc_hd__tapvpwrvgnd_1
XFILLER_26_204 VPWR VGND VPWR VGND sky130_ef_sc_hd__decap_12
XTAP_TAPCELL_ROW_36_232 VGND VPWR sky130_fd_sc_hd__tapvpwrvgnd_1
XPHY_EDGE_ROW_36_Left_78 VGND VGND VPWR VPWR sky130_fd_sc_hd__decap_3
X_601_ _049_ _052_ VGND VGND VPWR VPWR _054_ sky130_fd_sc_hd__or2_1
XFILLER_17_215 VGND VGND VPWR VPWR sky130_fd_sc_hd__decap_8
XFILLER_17_237 VGND VGND VPWR VPWR sky130_fd_sc_hd__decap_8
X_394_ _154_ _156_ _157_ _120_ VGND VGND VPWR VPWR _159_ sky130_fd_sc_hd__o211a_1
X_463_ _222_ _223_ _216_ VGND VGND VPWR VPWR _226_ sky130_fd_sc_hd__a21oi_1
X_532_ _234_ _291_ VGND VGND VPWR VPWR _292_ sky130_fd_sc_hd__nand2_1
XFILLER_4_141 VGND VGND VPWR VPWR sky130_fd_sc_hd__decap_4
XFILLER_4_185 VGND VGND VPWR VPWR sky130_fd_sc_hd__decap_6
XFILLER_31_240 VGND VGND VPWR VPWR sky130_fd_sc_hd__decap_3
Xfanout22 net25 VGND VGND VPWR VPWR net22 sky130_fd_sc_hd__clkbuf_2
XFILLER_22_240 VGND VGND VPWR VPWR sky130_fd_sc_hd__decap_3
XFILLER_8_3 VPWR VGND VPWR VGND sky130_ef_sc_hd__decap_12
XFILLER_1_199 VPWR VGND VPWR VGND sky130_ef_sc_hd__decap_12
XFILLER_38_73 VGND VGND VPWR VPWR sky130_fd_sc_hd__fill_2
X_515_ _252_ _270_ _275_ VGND VGND VPWR VPWR _276_ sky130_fd_sc_hd__a21oi_1
XFILLER_9_233 VGND VGND VPWR VPWR sky130_fd_sc_hd__fill_2
X_377_ symmetric_preadders.add_pair0.gen_fa\[4\].fa.b symmetric_preadders.add_pair0.gen_fa\[4\].fa.a
+ VGND VGND VPWR VPWR _142_ sky130_fd_sc_hd__or2_1
X_446_ _164_ _208_ VGND VGND VPWR VPWR _209_ sky130_fd_sc_hd__or2_1
XFILLER_10_221 VPWR VGND VPWR VGND sky130_ef_sc_hd__decap_12
XFILLER_24_53 VGND VGND VPWR VPWR sky130_fd_sc_hd__decap_3
XFILLER_24_97 VPWR VGND VPWR VGND sky130_ef_sc_hd__decap_12
XFILLER_40_41 VPWR VGND VPWR VGND sky130_ef_sc_hd__decap_12
XPHY_EDGE_ROW_39_Left_81 VGND VGND VPWR VPWR sky130_fd_sc_hd__decap_3
XFILLER_37_107 VGND VGND VPWR VPWR sky130_fd_sc_hd__decap_4
XFILLER_1_57 VPWR VGND VPWR VGND sky130_ef_sc_hd__decap_12
XPHY_EDGE_ROW_23_Left_65 VGND VGND VPWR VPWR sky130_fd_sc_hd__decap_3
X_429_ _172_ _191_ VGND VGND VPWR VPWR _193_ sky130_fd_sc_hd__nand2_1
Xinput1 data_in[0] VGND VGND VPWR VPWR net1 sky130_fd_sc_hd__clkbuf_1
XFILLER_36_184 VPWR VGND VPWR VGND sky130_ef_sc_hd__decap_12
XFILLER_19_42 VGND VGND VPWR VPWR sky130_fd_sc_hd__decap_6
XFILLER_27_184 VGND VGND VPWR VPWR sky130_fd_sc_hd__fill_2
XFILLER_25_6 VPWR VGND VPWR VGND sky130_ef_sc_hd__decap_12
XFILLER_33_176 VPWR VGND VPWR VGND sky130_ef_sc_hd__decap_12
XFILLER_24_165 VGND VGND VPWR VPWR sky130_fd_sc_hd__fill_2
XFILLER_21_54 VGND VGND VPWR VPWR sky130_fd_sc_hd__fill_2
XFILLER_21_76 VGND VGND VPWR VPWR sky130_fd_sc_hd__fill_1
XFILLER_15_110 VGND VGND VPWR VPWR sky130_fd_sc_hd__fill_2
XFILLER_15_154 VGND VGND VPWR VPWR sky130_fd_sc_hd__decap_4
XFILLER_15_187 VGND VGND VPWR VPWR sky130_fd_sc_hd__fill_1
XFILLER_23_3 VPWR VGND VPWR VGND sky130_ef_sc_hd__decap_12
XFILLER_21_113 VPWR VGND VPWR VGND sky130_ef_sc_hd__decap_12
XPHY_EDGE_ROW_10_Left_52 VGND VGND VPWR VPWR sky130_fd_sc_hd__decap_3
XFILLER_12_135 VGND VGND VPWR VPWR sky130_fd_sc_hd__decap_4
XFILLER_35_216 VGND VGND VPWR VPWR sky130_fd_sc_hd__decap_8
X_677_ coefficient_adder.add_final.gen_fa\[9\].fa.sum VGND VGND VPWR VPWR net21 sky130_fd_sc_hd__clkbuf_1
XTAP_TAPCELL_ROW_13_141 VGND VPWR sky130_fd_sc_hd__tapvpwrvgnd_1
XFILLER_7_161 VGND VGND VPWR VPWR sky130_fd_sc_hd__decap_6
XPHY_EDGE_ROW_9_Right_9 VGND VGND VPWR VPWR sky130_fd_sc_hd__decap_3
XTAP_TAPCELL_ROW_5_109 VGND VPWR sky130_fd_sc_hd__tapvpwrvgnd_1
XFILLER_26_216 VPWR VGND VPWR VGND sky130_ef_sc_hd__decap_12
XTAP_TAPCELL_ROW_36_233 VGND VPWR sky130_fd_sc_hd__tapvpwrvgnd_1
X_600_ _049_ _052_ VGND VGND VPWR VPWR _053_ sky130_fd_sc_hd__nand2_1
XFILLER_17_205 VGND VGND VPWR VPWR sky130_fd_sc_hd__decap_6
X_531_ _235_ _237_ VGND VGND VPWR VPWR _291_ sky130_fd_sc_hd__nand2_1
X_393_ _120_ _157_ _156_ _154_ VGND VGND VPWR VPWR _158_ sky130_fd_sc_hd__a211oi_1
X_462_ _216_ _222_ _223_ VGND VGND VPWR VPWR _225_ sky130_fd_sc_hd__nand3_1
XFILLER_4_197 VGND VGND VPWR VPWR sky130_fd_sc_hd__decap_8
XFILLER_4_35 VGND VGND VPWR VPWR sky130_fd_sc_hd__decap_8
Xfanout23 net25 VGND VGND VPWR VPWR net23 sky130_fd_sc_hd__clkbuf_2
XFILLER_13_55 VGND VGND VPWR VPWR sky130_fd_sc_hd__fill_1
XFILLER_38_41 VPWR VGND VPWR VGND sky130_ef_sc_hd__decap_12
XFILLER_38_85 VPWR VGND VPWR VGND sky130_ef_sc_hd__decap_12
X_514_ _273_ _274_ VGND VGND VPWR VPWR _275_ sky130_fd_sc_hd__xor2_1
X_376_ symmetric_preadders.add_pair0.gen_fa\[4\].fa.b symmetric_preadders.add_pair0.gen_fa\[4\].fa.a
+ VGND VGND VPWR VPWR _141_ sky130_fd_sc_hd__nor2_1
X_445_ _131_ _139_ _171_ VGND VGND VPWR VPWR _208_ sky130_fd_sc_hd__a21boi_1
XFILLER_10_233 VGND VGND VPWR VPWR sky130_fd_sc_hd__decap_8
XFILLER_40_53 VPWR VGND VPWR VGND sky130_ef_sc_hd__decap_12
XFILLER_1_69 VGND VGND VPWR VPWR sky130_fd_sc_hd__fill_1
X_428_ _172_ _191_ VGND VGND VPWR VPWR _192_ sky130_fd_sc_hd__nor2_1
X_359_ _106_ _124_ VGND VGND VPWR VPWR _125_ sky130_fd_sc_hd__nand2_1
Xinput2 data_in[1] VGND VGND VPWR VPWR net2 sky130_fd_sc_hd__clkbuf_1
XFILLER_36_141 VPWR VGND VPWR VGND sky130_ef_sc_hd__decap_12
XFILLER_36_174 VGND VGND VPWR VPWR sky130_fd_sc_hd__fill_2
XPHY_EDGE_ROW_40_Left_82 VGND VGND VPWR VPWR sky130_fd_sc_hd__decap_3
XFILLER_19_65 VPWR VGND VPWR VGND sky130_ef_sc_hd__decap_12
XFILLER_18_141 VGND VGND VPWR VPWR sky130_fd_sc_hd__decap_4
XFILLER_18_152 VPWR VGND VPWR VGND sky130_ef_sc_hd__decap_12
XFILLER_33_111 VGND VGND VPWR VPWR sky130_fd_sc_hd__fill_1
XFILLER_33_166 VGND VGND VPWR VPWR sky130_fd_sc_hd__fill_2
XFILLER_33_188 VPWR VGND VPWR VGND sky130_ef_sc_hd__decap_12
XFILLER_15_199 VGND VGND VPWR VPWR sky130_fd_sc_hd__fill_2
XFILLER_7_57 VPWR VGND VPWR VGND sky130_ef_sc_hd__decap_12
XFILLER_21_125 VPWR VGND VPWR VGND sky130_ef_sc_hd__decap_12
XFILLER_29_225 VPWR VGND VPWR VGND sky130_ef_sc_hd__decap_12
XFILLER_12_169 VGND VGND VPWR VPWR sky130_fd_sc_hd__fill_1
X_676_ coefficient_adder.add_final.gen_fa\[8\].fa.sum VGND VGND VPWR VPWR net20 sky130_fd_sc_hd__clkbuf_1
XTAP_TAPCELL_ROW_13_142 VGND VPWR sky130_fd_sc_hd__tapvpwrvgnd_1
XFILLER_7_195 VPWR VGND VPWR VGND sky130_ef_sc_hd__decap_12
XFILLER_26_228 VPWR VGND VPWR VGND sky130_ef_sc_hd__decap_12
XTAP_TAPCELL_ROW_36_234 VGND VPWR sky130_fd_sc_hd__tapvpwrvgnd_1
X_461_ _216_ _222_ _223_ VGND VGND VPWR VPWR _224_ sky130_fd_sc_hd__and3_1
XFILLER_32_209 VPWR VGND VPWR VGND sky130_ef_sc_hd__decap_12
X_530_ _287_ _288_ VGND VGND VPWR VPWR _290_ sky130_fd_sc_hd__xor2_1
X_392_ _112_ _119_ _122_ _090_ VGND VGND VPWR VPWR _157_ sky130_fd_sc_hd__a2bb2o_1
X_659_ clknet_2_2__leaf_clk _039_ VGND VGND VPWR VPWR symmetric_preadders.add_pair0.gen_fa\[7\].fa.a
+ sky130_fd_sc_hd__dfxtp_1
Xfanout24 net25 VGND VGND VPWR VPWR net24 sky130_fd_sc_hd__buf_1
XFILLER_1_102 VGND VGND VPWR VPWR sky130_fd_sc_hd__decap_8
XFILLER_13_67 VPWR VGND VPWR VGND sky130_ef_sc_hd__decap_12
XFILLER_38_97 VGND VGND VPWR VPWR sky130_fd_sc_hd__decap_4
XFILLER_38_53 VPWR VGND VPWR VGND sky130_ef_sc_hd__decap_12
X_444_ _205_ _206_ VGND VGND VPWR VPWR _207_ sky130_fd_sc_hd__and2b_1
X_513_ _211_ _244_ _248_ _245_ VGND VGND VPWR VPWR _274_ sky130_fd_sc_hd__a31o_1
XFILLER_9_246 VGND VGND VPWR VPWR sky130_fd_sc_hd__fill_1
X_375_ _132_ _139_ VGND VGND VPWR VPWR _140_ sky130_fd_sc_hd__xnor2_1
XFILLER_40_65 VPWR VGND VPWR VGND sky130_ef_sc_hd__decap_12
XFILLER_1_15 VPWR VGND VPWR VGND sky130_ef_sc_hd__decap_12
X_358_ _121_ _123_ VGND VGND VPWR VPWR _124_ sky130_fd_sc_hd__xnor2_1
X_427_ _188_ _190_ VGND VGND VPWR VPWR _191_ sky130_fd_sc_hd__xnor2_1
XPHY_EDGE_ROW_18_Right_18 VGND VGND VPWR VPWR sky130_fd_sc_hd__decap_3
Xinput3 data_in[2] VGND VGND VPWR VPWR net3 sky130_fd_sc_hd__clkbuf_1
XPHY_EDGE_ROW_27_Right_27 VGND VGND VPWR VPWR sky130_fd_sc_hd__decap_3
XFILLER_36_153 VGND VGND VPWR VPWR sky130_fd_sc_hd__decap_8
XFILLER_36_197 VGND VGND VPWR VPWR sky130_fd_sc_hd__decap_6
XFILLER_10_79 VGND VGND VPWR VPWR sky130_fd_sc_hd__decap_4
XPHY_EDGE_ROW_36_Right_36 VGND VGND VPWR VPWR sky130_fd_sc_hd__decap_3
XFILLER_19_77 VPWR VGND VPWR VGND sky130_ef_sc_hd__decap_12
XFILLER_19_109 VGND VGND VPWR VPWR sky130_fd_sc_hd__decap_3
XFILLER_18_164 VPWR VGND VPWR VGND sky130_ef_sc_hd__decap_12
XFILLER_18_197 VGND VGND VPWR VPWR sky130_fd_sc_hd__decap_8
XFILLER_15_167 VGND VGND VPWR VPWR sky130_fd_sc_hd__fill_1
XFILLER_7_69 VPWR VGND VPWR VGND sky130_ef_sc_hd__decap_12
XFILLER_21_137 VGND VGND VPWR VPWR sky130_fd_sc_hd__fill_1
XFILLER_29_237 VGND VGND VPWR VPWR sky130_fd_sc_hd__decap_8
XPHY_EDGE_ROW_0_Right_0 VGND VGND VPWR VPWR sky130_fd_sc_hd__decap_3
XFILLER_16_56 VGND VGND VPWR VPWR sky130_fd_sc_hd__fill_1
XTAP_TAPCELL_ROW_22_176 VGND VPWR sky130_fd_sc_hd__tapvpwrvgnd_1
XFILLER_32_99 VGND VGND VPWR VPWR sky130_fd_sc_hd__decap_8
X_675_ coefficient_adder.add_final.gen_fa\[7\].fa.sum VGND VGND VPWR VPWR net19 sky130_fd_sc_hd__clkbuf_1
XTAP_TAPCELL_ROW_13_143 VGND VPWR sky130_fd_sc_hd__tapvpwrvgnd_1
XTAP_TAPCELL_ROW_36_235 VGND VPWR sky130_fd_sc_hd__tapvpwrvgnd_1
X_391_ _146_ _147_ _153_ VGND VGND VPWR VPWR _156_ sky130_fd_sc_hd__a21oi_1
XFILLER_27_55 VGND VGND VPWR VPWR sky130_fd_sc_hd__fill_1
X_460_ _173_ _221_ _220_ VGND VGND VPWR VPWR _223_ sky130_fd_sc_hd__a21bo_1
XFILLER_40_243 VGND VGND VPWR VPWR sky130_fd_sc_hd__fill_1
XFILLER_4_15 VPWR VGND VPWR VGND sky130_ef_sc_hd__decap_12
X_589_ net22 net60 VGND VGND VPWR VPWR _042_ sky130_fd_sc_hd__and2b_1
XFILLER_16_240 VGND VGND VPWR VPWR sky130_fd_sc_hd__decap_3
X_658_ clknet_2_2__leaf_clk _038_ VGND VGND VPWR VPWR symmetric_preadders.add_pair0.gen_fa\[6\].fa.a
+ sky130_fd_sc_hd__dfxtp_1
Xfanout25 net9 VGND VGND VPWR VPWR net25 sky130_fd_sc_hd__clkbuf_2
XFILLER_13_57 VGND VGND VPWR VPWR sky130_fd_sc_hd__fill_2
XFILLER_13_79 VPWR VGND VPWR VGND sky130_ef_sc_hd__decap_12
XFILLER_1_147 VGND VGND VPWR VPWR sky130_fd_sc_hd__decap_4
XFILLER_38_65 VGND VGND VPWR VPWR sky130_fd_sc_hd__decap_8
XFILLER_1_169 VPWR VGND VPWR VGND sky130_ef_sc_hd__decap_12
X_512_ _271_ _272_ VGND VGND VPWR VPWR _273_ sky130_fd_sc_hd__nand2_1
XFILLER_9_225 VGND VGND VPWR VPWR sky130_fd_sc_hd__decap_8
X_374_ _137_ _138_ VGND VGND VPWR VPWR _139_ sky130_fd_sc_hd__nand2_1
X_443_ _202_ _203_ _171_ VGND VGND VPWR VPWR _206_ sky130_fd_sc_hd__a21o_1
XTAP_TAPCELL_ROW_30_208 VGND VPWR sky130_fd_sc_hd__tapvpwrvgnd_1
XFILLER_40_77 VGND VGND VPWR VPWR sky130_fd_sc_hd__decap_6
XFILLER_6_3 VPWR VGND VPWR VGND sky130_ef_sc_hd__decap_12
XFILLER_1_27 VPWR VGND VPWR VGND sky130_ef_sc_hd__decap_12
XFILLER_1_49 VGND VGND VPWR VPWR sky130_fd_sc_hd__decap_6
X_357_ _090_ _122_ VGND VGND VPWR VPWR _123_ sky130_fd_sc_hd__and2_1
X_426_ _120_ _155_ _157_ _156_ VGND VGND VPWR VPWR _190_ sky130_fd_sc_hd__a31o_1
XFILLER_39_3 VPWR VGND VPWR VGND sky130_ef_sc_hd__decap_12
XTAP_TAPCELL_ROW_1_92 VGND VPWR sky130_fd_sc_hd__tapvpwrvgnd_1
Xinput4 data_in[3] VGND VGND VPWR VPWR net4 sky130_fd_sc_hd__clkbuf_1
Xclkbuf_2_1__f_clk clknet_0_clk VGND VGND VPWR VPWR clknet_2_1__leaf_clk sky130_fd_sc_hd__clkbuf_16
XFILLER_19_23 VGND VGND VPWR VPWR sky130_fd_sc_hd__decap_3
XFILLER_19_89 VPWR VGND VPWR VGND sky130_ef_sc_hd__decap_12
XFILLER_27_110 VGND VGND VPWR VPWR sky130_fd_sc_hd__fill_2
XFILLER_35_55 VGND VGND VPWR VPWR sky130_fd_sc_hd__fill_1
XPHY_EDGE_ROW_27_Left_69 VGND VGND VPWR VPWR sky130_fd_sc_hd__decap_3
XFILLER_18_132 VGND VGND VPWR VPWR sky130_fd_sc_hd__decap_8
XFILLER_18_176 VPWR VGND VPWR VGND sky130_ef_sc_hd__decap_12
X_409_ symmetric_preadders.add_pair0.gen_fa\[5\].fa.b symmetric_preadders.add_pair0.gen_fa\[5\].fa.a
+ VGND VGND VPWR VPWR _173_ sky130_fd_sc_hd__or2_1
XFILLER_15_102 VGND VGND VPWR VPWR sky130_fd_sc_hd__decap_8
XFILLER_15_113 VGND VGND VPWR VPWR sky130_fd_sc_hd__fill_1
XFILLER_7_15 VPWR VGND VPWR VGND sky130_ef_sc_hd__decap_12
XFILLER_30_149 VGND VGND VPWR VPWR sky130_fd_sc_hd__decap_3
XTAP_TAPCELL_ROW_16_152 VGND VPWR sky130_fd_sc_hd__tapvpwrvgnd_1
XFILLER_29_205 VGND VGND VPWR VPWR sky130_fd_sc_hd__decap_4
XFILLER_29_216 VGND VGND VPWR VPWR sky130_fd_sc_hd__decap_8
XTAP_TAPCELL_ROW_39_244 VGND VPWR sky130_fd_sc_hd__tapvpwrvgnd_1
XFILLER_8_109 VGND VGND VPWR VPWR sky130_fd_sc_hd__decap_6
XFILLER_20_193 VGND VGND VPWR VPWR sky130_fd_sc_hd__decap_3
XTAP_TAPCELL_ROW_22_177 VGND VPWR sky130_fd_sc_hd__tapvpwrvgnd_1
XFILLER_32_67 VGND VGND VPWR VPWR sky130_fd_sc_hd__fill_1
X_674_ coefficient_adder.add_final.gen_fa\[6\].fa.sum VGND VGND VPWR VPWR net18 sky130_fd_sc_hd__clkbuf_1
XPHY_EDGE_ROW_14_Left_56 VGND VGND VPWR VPWR sky130_fd_sc_hd__decap_3
X_390_ _146_ _147_ _153_ VGND VGND VPWR VPWR _155_ sky130_fd_sc_hd__nand3_1
XFILLER_4_145 VGND VGND VPWR VPWR sky130_fd_sc_hd__fill_1
XFILLER_4_27 VGND VGND VPWR VPWR sky130_fd_sc_hd__fill_1
X_657_ clknet_2_2__leaf_clk _037_ VGND VGND VPWR VPWR symmetric_preadders.add_pair0.gen_fa\[5\].fa.a
+ sky130_fd_sc_hd__dfxtp_1
X_588_ net22 net66 VGND VGND VPWR VPWR _041_ sky130_fd_sc_hd__and2b_1
Xfanout26 net9 VGND VGND VPWR VPWR net26 sky130_fd_sc_hd__buf_2
X_511_ symmetric_preadders.add_pair1.gen_fa\[7\].fa.b symmetric_preadders.add_pair1.gen_fa\[7\].fa.a
+ VGND VGND VPWR VPWR _272_ sky130_fd_sc_hd__nand2_1
X_373_ _100_ _136_ _135_ _133_ VGND VGND VPWR VPWR _138_ sky130_fd_sc_hd__a211o_1
X_442_ _171_ _202_ _203_ VGND VGND VPWR VPWR _205_ sky130_fd_sc_hd__and3_1
XTAP_TAPCELL_ROW_30_209 VGND VPWR sky130_fd_sc_hd__tapvpwrvgnd_1
XFILLER_0_181 VPWR VGND VPWR VGND sky130_ef_sc_hd__decap_12
XFILLER_39_196 VPWR VGND VPWR VGND sky130_ef_sc_hd__decap_12
XFILLER_1_39 VGND VGND VPWR VPWR sky130_fd_sc_hd__decap_4
X_356_ _083_ _088_ _089_ _060_ _057_ VGND VGND VPWR VPWR _122_ sky130_fd_sc_hd__a311o_1
X_425_ _120_ _157_ _156_ VGND VGND VPWR VPWR _189_ sky130_fd_sc_hd__a21o_1
XTAP_TAPCELL_ROW_1_93 VGND VPWR sky130_fd_sc_hd__tapvpwrvgnd_1
Xinput5 data_in[4] VGND VGND VPWR VPWR net5 sky130_fd_sc_hd__clkbuf_1
XFILLER_10_26 VGND VGND VPWR VPWR sky130_fd_sc_hd__fill_2
XFILLER_27_177 VGND VGND VPWR VPWR sky130_fd_sc_hd__fill_1
XFILLER_27_199 VGND VGND VPWR VPWR sky130_fd_sc_hd__decap_6
XPHY_EDGE_ROW_2_Left_44 VGND VGND VPWR VPWR sky130_fd_sc_hd__decap_3
XFILLER_2_221 VPWR VGND VPWR VGND sky130_ef_sc_hd__decap_12
XFILLER_18_188 VGND VGND VPWR VPWR sky130_fd_sc_hd__decap_8
X_408_ _165_ _171_ VGND VGND VPWR VPWR _172_ sky130_fd_sc_hd__xnor2_1
XFILLER_33_158 VGND VGND VPWR VPWR sky130_fd_sc_hd__decap_8
X_339_ _103_ _104_ VGND VGND VPWR VPWR _105_ sky130_fd_sc_hd__xor2_1
XFILLER_2_93 VGND VGND VPWR VPWR sky130_fd_sc_hd__fill_1
XFILLER_15_158 VGND VGND VPWR VPWR sky130_fd_sc_hd__fill_1
XFILLER_7_27 VPWR VGND VPWR VGND sky130_ef_sc_hd__decap_12
XFILLER_16_6 VPWR VGND VPWR VGND sky130_ef_sc_hd__decap_12
XTAP_TAPCELL_ROW_16_153 VGND VPWR sky130_fd_sc_hd__tapvpwrvgnd_1
XTAP_TAPCELL_ROW_39_245 VGND VPWR sky130_fd_sc_hd__tapvpwrvgnd_1
XFILLER_12_139 VGND VGND VPWR VPWR sky130_fd_sc_hd__fill_1
XTAP_TAPCELL_ROW_22_178 VGND VPWR sky130_fd_sc_hd__tapvpwrvgnd_1
XFILLER_32_57 VGND VGND VPWR VPWR sky130_fd_sc_hd__fill_2
X_673_ coefficient_adder.add_final.gen_fa\[5\].fa.sum VGND VGND VPWR VPWR net17 sky130_fd_sc_hd__clkbuf_1
XFILLER_14_3 VPWR VGND VPWR VGND sky130_ef_sc_hd__decap_12
XFILLER_27_57 VPWR VGND VPWR VGND sky130_ef_sc_hd__decap_12
XFILLER_40_201 VPWR VGND VPWR VGND sky130_ef_sc_hd__decap_12
XPHY_EDGE_ROW_31_Left_73 VGND VGND VPWR VPWR sky130_fd_sc_hd__decap_3
X_587_ net23 net53 VGND VGND VPWR VPWR _040_ sky130_fd_sc_hd__and2b_1
X_656_ clknet_2_0__leaf_clk _036_ VGND VGND VPWR VPWR symmetric_preadders.add_pair0.gen_fa\[4\].fa.a
+ sky130_fd_sc_hd__dfxtp_1
XFILLER_31_212 VPWR VGND VPWR VGND sky130_ef_sc_hd__decap_12
XFILLER_13_15 VPWR VGND VPWR VGND sky130_ef_sc_hd__decap_12
Xfanout27 net9 VGND VGND VPWR VPWR net27 sky130_fd_sc_hd__clkbuf_2
X_510_ symmetric_preadders.add_pair1.gen_fa\[7\].fa.b symmetric_preadders.add_pair1.gen_fa\[7\].fa.a
+ VGND VGND VPWR VPWR _271_ sky130_fd_sc_hd__or2_1
X_441_ _202_ _203_ VGND VGND VPWR VPWR _204_ sky130_fd_sc_hd__nand2_1
XFILLER_9_238 VGND VGND VPWR VPWR sky130_fd_sc_hd__decap_8
XFILLER_13_245 VGND VGND VPWR VPWR sky130_fd_sc_hd__fill_2
X_372_ _133_ _135_ _136_ _100_ VGND VGND VPWR VPWR _137_ sky130_fd_sc_hd__o211ai_1
XFILLER_0_193 VGND VGND VPWR VPWR sky130_fd_sc_hd__decap_3
X_639_ clknet_2_1__leaf_clk _019_ VGND VGND VPWR VPWR symmetric_preadders.add_pair2.gen_fa\[3\].fa.a
+ sky130_fd_sc_hd__dfxtp_1
XFILLER_24_25 VGND VGND VPWR VPWR sky130_fd_sc_hd__decap_3
X_424_ _178_ _185_ VGND VGND VPWR VPWR _188_ sky130_fd_sc_hd__xnor2_1
X_355_ _112_ _119_ VGND VGND VPWR VPWR _121_ sky130_fd_sc_hd__xnor2_1
XTAP_TAPCELL_ROW_1_94 VGND VPWR sky130_fd_sc_hd__tapvpwrvgnd_1
Xinput6 data_in[5] VGND VGND VPWR VPWR net6 sky130_fd_sc_hd__clkbuf_1
XFILLER_36_101 VGND VGND VPWR VPWR sky130_fd_sc_hd__decap_4
XFILLER_27_167 VGND VGND VPWR VPWR sky130_fd_sc_hd__fill_1
XFILLER_35_57 VPWR VGND VPWR VGND sky130_ef_sc_hd__decap_12
XPHY_EDGE_ROW_14_Right_14 VGND VGND VPWR VPWR sky130_fd_sc_hd__decap_3
XFILLER_2_233 VPWR VGND VPWR VGND sky130_ef_sc_hd__decap_12
XPHY_EDGE_ROW_23_Right_23 VGND VGND VPWR VPWR sky130_fd_sc_hd__decap_3
XFILLER_18_112 VGND VGND VPWR VPWR sky130_fd_sc_hd__decap_3
XFILLER_18_145 VGND VGND VPWR VPWR sky130_fd_sc_hd__fill_1
X_338_ _063_ _072_ _075_ _073_ VGND VGND VPWR VPWR _104_ sky130_fd_sc_hd__a31o_1
X_407_ _169_ _170_ VGND VGND VPWR VPWR _171_ sky130_fd_sc_hd__xor2_2
XPHY_EDGE_ROW_32_Right_32 VGND VGND VPWR VPWR sky130_fd_sc_hd__decap_3
XFILLER_33_148 VGND VGND VPWR VPWR sky130_fd_sc_hd__fill_2
XPHY_EDGE_ROW_41_Right_41 VGND VGND VPWR VPWR sky130_fd_sc_hd__decap_3
XFILLER_2_83 VGND VGND VPWR VPWR sky130_fd_sc_hd__fill_1
XFILLER_15_137 VGND VGND VPWR VPWR sky130_fd_sc_hd__fill_1
XFILLER_23_181 VGND VGND VPWR VPWR sky130_fd_sc_hd__decap_6
XFILLER_30_107 VGND VGND VPWR VPWR sky130_fd_sc_hd__decap_8
XFILLER_7_39 VPWR VGND VPWR VGND sky130_ef_sc_hd__decap_12
XTAP_TAPCELL_ROW_16_154 VGND VPWR sky130_fd_sc_hd__tapvpwrvgnd_1
XTAP_TAPCELL_ROW_39_246 VGND VPWR sky130_fd_sc_hd__tapvpwrvgnd_1
XFILLER_16_26 VGND VGND VPWR VPWR sky130_fd_sc_hd__fill_2
XTAP_TAPCELL_ROW_22_179 VGND VPWR sky130_fd_sc_hd__tapvpwrvgnd_1
X_672_ coefficient_adder.add_final.gen_fa\[4\].fa.sum VGND VGND VPWR VPWR net16 sky130_fd_sc_hd__clkbuf_1
XFILLER_28_240 VGND VGND VPWR VPWR sky130_fd_sc_hd__decap_6
XFILLER_7_111 VGND VGND VPWR VPWR sky130_fd_sc_hd__fill_1
XFILLER_11_140 VGND VGND VPWR VPWR sky130_fd_sc_hd__decap_8
XFILLER_11_184 VPWR VGND VPWR VGND sky130_ef_sc_hd__decap_12
XFILLER_34_221 VPWR VGND VPWR VGND sky130_ef_sc_hd__decap_12
XPHY_EDGE_ROW_4_Right_4 VGND VGND VPWR VPWR sky130_fd_sc_hd__decap_3
XFILLER_27_69 VPWR VGND VPWR VGND sky130_ef_sc_hd__decap_12
XFILLER_40_213 VPWR VGND VPWR VGND sky130_ef_sc_hd__decap_12
X_586_ net26 net8 VGND VGND VPWR VPWR _039_ sky130_fd_sc_hd__and2b_1
X_655_ clknet_2_0__leaf_clk _035_ VGND VGND VPWR VPWR symmetric_preadders.add_pair0.gen_fa\[3\].fa.a
+ sky130_fd_sc_hd__dfxtp_1
XTAP_TAPCELL_ROW_41_252 VGND VPWR sky130_fd_sc_hd__tapvpwrvgnd_1
XFILLER_13_27 VPWR VGND VPWR VGND sky130_ef_sc_hd__decap_12
X_371_ _063_ _072_ _075_ _101_ _073_ VGND VGND VPWR VPWR _136_ sky130_fd_sc_hd__a311o_1
X_440_ _166_ _201_ _200_ VGND VGND VPWR VPWR _203_ sky130_fd_sc_hd__a21o_1
X_638_ clknet_2_1__leaf_clk _018_ VGND VGND VPWR VPWR symmetric_preadders.add_pair2.gen_fa\[2\].fa.a
+ sky130_fd_sc_hd__dfxtp_1
X_569_ net27 net51 VGND VGND VPWR VPWR _022_ sky130_fd_sc_hd__and2b_1
XFILLER_39_110 VGND VGND VPWR VPWR sky130_fd_sc_hd__fill_2
XFILLER_24_15 VGND VGND VPWR VPWR sky130_fd_sc_hd__decap_4
XFILLER_6_209 VPWR VGND VPWR VGND sky130_ef_sc_hd__decap_12
X_354_ _112_ _119_ VGND VGND VPWR VPWR _120_ sky130_fd_sc_hd__nand2_1
X_423_ _178_ _185_ VGND VGND VPWR VPWR _187_ sky130_fd_sc_hd__and2_1
XTAP_TAPCELL_ROW_1_95 VGND VPWR sky130_fd_sc_hd__tapvpwrvgnd_1
Xinput7 data_in[6] VGND VGND VPWR VPWR net7 sky130_fd_sc_hd__clkbuf_1
XFILLER_36_113 VGND VGND VPWR VPWR sky130_fd_sc_hd__decap_4
XFILLER_19_15 VGND VGND VPWR VPWR sky130_fd_sc_hd__decap_8
XFILLER_35_69 VPWR VGND VPWR VGND sky130_ef_sc_hd__decap_12
XFILLER_4_3 VPWR VGND VPWR VGND sky130_ef_sc_hd__decap_12
XFILLER_2_245 VGND VGND VPWR VPWR sky130_fd_sc_hd__fill_2
XFILLER_33_105 VGND VGND VPWR VPWR sky130_fd_sc_hd__decap_6
XFILLER_41_182 VPWR VGND VPWR VGND sky130_ef_sc_hd__decap_12
X_337_ _100_ _102_ VGND VGND VPWR VPWR _103_ sky130_fd_sc_hd__nand2_1
X_406_ _100_ _134_ _136_ _135_ VGND VGND VPWR VPWR _170_ sky130_fd_sc_hd__a31o_1
XFILLER_26_190 VGND VGND VPWR VPWR sky130_fd_sc_hd__fill_1
XFILLER_37_3 VPWR VGND VPWR VGND sky130_ef_sc_hd__decap_12
XFILLER_24_116 VPWR VGND VPWR VGND sky130_ef_sc_hd__decap_12
XTAP_TAPCELL_ROW_25_188 VGND VPWR sky130_fd_sc_hd__tapvpwrvgnd_1
XTAP_TAPCELL_ROW_16_155 VGND VPWR sky130_fd_sc_hd__tapvpwrvgnd_1
XTAP_TAPCELL_ROW_39_247 VGND VPWR sky130_fd_sc_hd__tapvpwrvgnd_1
XFILLER_32_26 VGND VGND VPWR VPWR sky130_fd_sc_hd__fill_2
XFILLER_20_163 VGND VGND VPWR VPWR sky130_fd_sc_hd__fill_1
XFILLER_20_185 VGND VGND VPWR VPWR sky130_fd_sc_hd__decap_8
X_671_ coefficient_adder.add_final.gen_fa\[3\].fa.sum VGND VGND VPWR VPWR net15 sky130_fd_sc_hd__clkbuf_1
XFILLER_11_196 VPWR VGND VPWR VGND sky130_ef_sc_hd__decap_12
XFILLER_7_167 VGND VGND VPWR VPWR sky130_fd_sc_hd__fill_1
XFILLER_21_6 VPWR VGND VPWR VGND sky130_ef_sc_hd__decap_12
XFILLER_34_233 VPWR VGND VPWR VGND sky130_ef_sc_hd__decap_12
XFILLER_8_72 VPWR VGND VPWR VGND sky130_ef_sc_hd__decap_12
XFILLER_8_61 VGND VGND VPWR VPWR sky130_fd_sc_hd__decap_3
XTAP_TAPCELL_ROW_4_104 VGND VPWR sky130_fd_sc_hd__tapvpwrvgnd_1
XFILLER_27_15 VPWR VGND VPWR VGND sky130_ef_sc_hd__decap_12
XFILLER_40_225 VPWR VGND VPWR VGND sky130_ef_sc_hd__decap_12
XTAP_TAPCELL_ROW_10_128 VGND VPWR sky130_fd_sc_hd__tapvpwrvgnd_1
X_654_ clknet_2_0__leaf_clk _034_ VGND VGND VPWR VPWR symmetric_preadders.add_pair0.gen_fa\[2\].fa.a
+ sky130_fd_sc_hd__dfxtp_1
XFILLER_17_81 VGND VGND VPWR VPWR sky130_fd_sc_hd__decap_8
X_585_ net26 net7 VGND VGND VPWR VPWR _038_ sky130_fd_sc_hd__and2b_1
XFILLER_31_225 VPWR VGND VPWR VGND sky130_ef_sc_hd__decap_12
XTAP_TAPCELL_ROW_41_253 VGND VPWR sky130_fd_sc_hd__tapvpwrvgnd_1
XFILLER_13_39 VPWR VGND VPWR VGND sky130_ef_sc_hd__decap_12
XFILLER_1_129 VGND VGND VPWR VPWR sky130_fd_sc_hd__fill_2
XFILLER_13_225 VPWR VGND VPWR VGND sky130_ef_sc_hd__decap_12
X_370_ symmetric_preadders.add_pair2.gen_fa\[4\].fa.b symmetric_preadders.add_pair2.gen_fa\[4\].fa.a
+ VGND VGND VPWR VPWR _135_ sky130_fd_sc_hd__and2_1
XFILLER_9_218 VGND VGND VPWR VPWR sky130_fd_sc_hd__decap_6
X_637_ clknet_2_1__leaf_clk _017_ VGND VGND VPWR VPWR symmetric_preadders.add_pair2.gen_fa\[1\].fa.a
+ sky130_fd_sc_hd__dfxtp_1
X_568_ net27 net44 VGND VGND VPWR VPWR _021_ sky130_fd_sc_hd__and2b_1
X_499_ _225_ _259_ _258_ VGND VGND VPWR VPWR _261_ sky130_fd_sc_hd__a21oi_1
XFILLER_39_166 VGND VGND VPWR VPWR sky130_fd_sc_hd__fill_2
XFILLER_5_95 VGND VGND VPWR VPWR sky130_fd_sc_hd__fill_1
XFILLER_39_188 VGND VGND VPWR VPWR sky130_fd_sc_hd__fill_1
XFILLER_40_15 VPWR VGND VPWR VGND sky130_ef_sc_hd__decap_12
X_353_ _116_ _118_ VGND VGND VPWR VPWR _119_ sky130_fd_sc_hd__xor2_1
X_422_ _178_ _185_ VGND VGND VPWR VPWR _186_ sky130_fd_sc_hd__or2_1
Xinput8 data_in[7] VGND VGND VPWR VPWR net8 sky130_fd_sc_hd__clkbuf_1
XFILLER_10_18 VGND VGND VPWR VPWR sky130_fd_sc_hd__decap_8
XFILLER_10_29 VPWR VGND VPWR VGND sky130_ef_sc_hd__decap_12
XFILLER_27_125 VPWR VGND VPWR VGND sky130_ef_sc_hd__decap_12
XFILLER_35_15 VPWR VGND VPWR VGND sky130_ef_sc_hd__decap_12
XFILLER_27_169 VGND VGND VPWR VPWR sky130_fd_sc_hd__decap_8
XFILLER_35_180 VGND VGND VPWR VPWR sky130_fd_sc_hd__fill_2
XFILLER_26_180 VGND VGND VPWR VPWR sky130_fd_sc_hd__fill_1
XFILLER_41_194 VGND VGND VPWR VPWR sky130_fd_sc_hd__fill_2
XFILLER_41_161 VGND VGND VPWR VPWR sky130_fd_sc_hd__decap_3
X_336_ symmetric_preadders.add_pair2.gen_fa\[3\].fa.b symmetric_preadders.add_pair2.gen_fa\[3\].fa.a
+ VGND VGND VPWR VPWR _102_ sky130_fd_sc_hd__nand2_1
X_405_ _166_ _168_ VGND VGND VPWR VPWR _169_ sky130_fd_sc_hd__nand2_1
XFILLER_2_85 VGND VGND VPWR VPWR sky130_fd_sc_hd__decap_8
XTAP_TAPCELL_ROW_19_164 VGND VPWR sky130_fd_sc_hd__tapvpwrvgnd_1
XFILLER_24_128 VPWR VGND VPWR VGND sky130_ef_sc_hd__decap_12
XFILLER_32_194 VGND VGND VPWR VPWR sky130_fd_sc_hd__fill_2
XPHY_EDGE_ROW_6_Left_48 VGND VGND VPWR VPWR sky130_fd_sc_hd__decap_3
XFILLER_15_117 VPWR VGND VPWR VGND sky130_ef_sc_hd__decap_12
XFILLER_23_161 VGND VGND VPWR VPWR sky130_fd_sc_hd__decap_6
XTAP_TAPCELL_ROW_25_189 VGND VPWR sky130_fd_sc_hd__tapvpwrvgnd_1
XFILLER_11_94 VGND VGND VPWR VPWR sky130_fd_sc_hd__fill_1
XFILLER_38_209 VPWR VGND VPWR VGND sky130_ef_sc_hd__decap_12
X_319_ symmetric_preadders.add_pair0.gen_fa\[2\].fa.b symmetric_preadders.add_pair0.gen_fa\[2\].fa.a
+ VGND VGND VPWR VPWR _086_ sky130_fd_sc_hd__and2_1
XFILLER_29_209 VGND VGND VPWR VPWR sky130_fd_sc_hd__fill_1
XFILLER_20_120 VPWR VGND VPWR VGND sky130_ef_sc_hd__decap_12
XFILLER_20_197 VPWR VGND VPWR VGND sky130_ef_sc_hd__decap_12
X_670_ coefficient_adder.add_final.gen_fa\[2\].fa.sum VGND VGND VPWR VPWR net14 sky130_fd_sc_hd__clkbuf_1
XFILLER_7_113 VPWR VGND VPWR VGND sky130_ef_sc_hd__decap_12
XFILLER_34_245 VGND VGND VPWR VPWR sky130_fd_sc_hd__fill_2
XTAP_TAPCELL_ROW_4_105 VGND VPWR sky130_fd_sc_hd__tapvpwrvgnd_1
XFILLER_27_27 VPWR VGND VPWR VGND sky130_ef_sc_hd__decap_12
XFILLER_25_223 VGND VGND VPWR VPWR sky130_fd_sc_hd__fill_1
XFILLER_25_245 VGND VGND VPWR VPWR sky130_fd_sc_hd__fill_2
XFILLER_40_237 VGND VGND VPWR VPWR sky130_fd_sc_hd__decap_6
XTAP_TAPCELL_ROW_10_129 VGND VPWR sky130_fd_sc_hd__tapvpwrvgnd_1
XPHY_EDGE_ROW_9_Left_51 VGND VGND VPWR VPWR sky130_fd_sc_hd__decap_3
X_653_ clknet_2_0__leaf_clk _033_ VGND VGND VPWR VPWR symmetric_preadders.add_pair0.gen_fa\[1\].fa.a
+ sky130_fd_sc_hd__dfxtp_1
XFILLER_16_223 VPWR VGND VPWR VGND sky130_ef_sc_hd__decap_12
XTAP_TAPCELL_ROW_41_254 VGND VPWR sky130_fd_sc_hd__tapvpwrvgnd_1
X_584_ net26 net6 VGND VGND VPWR VPWR _037_ sky130_fd_sc_hd__and2b_1
XFILLER_31_204 VGND VGND VPWR VPWR sky130_fd_sc_hd__decap_4
XFILLER_12_3 VPWR VGND VPWR VGND sky130_ef_sc_hd__decap_12
XFILLER_38_15 VPWR VGND VPWR VGND sky130_ef_sc_hd__decap_12
XFILLER_13_237 VGND VGND VPWR VPWR sky130_fd_sc_hd__decap_8
XPHY_EDGE_ROW_35_Left_77 VGND VGND VPWR VPWR sky130_fd_sc_hd__decap_3
XFILLER_0_141 VGND VGND VPWR VPWR sky130_fd_sc_hd__decap_8
X_636_ clknet_2_1__leaf_clk _016_ VGND VGND VPWR VPWR symmetric_preadders.add_pair2.gen_fa\[0\].fa.a
+ sky130_fd_sc_hd__dfxtp_1
X_567_ net24 net46 VGND VGND VPWR VPWR _020_ sky130_fd_sc_hd__and2b_1
X_498_ _225_ _258_ _259_ VGND VGND VPWR VPWR _260_ sky130_fd_sc_hd__and3_1
XFILLER_5_30 VGND VGND VPWR VPWR sky130_fd_sc_hd__decap_4
XFILLER_39_101 VGND VGND VPWR VPWR sky130_fd_sc_hd__fill_1
XFILLER_40_27 VGND VGND VPWR VPWR sky130_fd_sc_hd__fill_1
X_421_ _183_ _184_ VGND VGND VPWR VPWR _185_ sky130_fd_sc_hd__or2_1
X_352_ _081_ _117_ VGND VGND VPWR VPWR _118_ sky130_fd_sc_hd__nand2_1
XFILLER_14_72 VPWR VGND VPWR VGND sky130_ef_sc_hd__decap_12
XFILLER_5_211 VPWR VGND VPWR VGND sky130_ef_sc_hd__decap_12
XFILLER_5_200 VGND VGND VPWR VPWR sky130_fd_sc_hd__fill_2
Xinput9 reset VGND VGND VPWR VPWR net9 sky130_fd_sc_hd__buf_1
X_619_ _069_ _070_ VGND VGND VPWR VPWR _071_ sky130_fd_sc_hd__nor2_1
XFILLER_36_137 VGND VGND VPWR VPWR sky130_fd_sc_hd__decap_3
XFILLER_27_137 VGND VGND VPWR VPWR sky130_fd_sc_hd__fill_2
XFILLER_27_159 VGND VGND VPWR VPWR sky130_fd_sc_hd__decap_8
XFILLER_35_27 VPWR VGND VPWR VGND sky130_ef_sc_hd__decap_12
X_404_ symmetric_preadders.add_pair2.gen_fa\[5\].fa.b symmetric_preadders.add_pair2.gen_fa\[5\].fa.a
+ VGND VGND VPWR VPWR _168_ sky130_fd_sc_hd__nand2_1
XFILLER_33_118 VPWR VGND VPWR VGND sky130_ef_sc_hd__decap_12
XFILLER_41_81 VGND VGND VPWR VPWR sky130_fd_sc_hd__decap_3
XPHY_EDGE_ROW_38_Left_80 VGND VGND VPWR VPWR sky130_fd_sc_hd__decap_3
X_335_ symmetric_preadders.add_pair2.gen_fa\[3\].fa.b symmetric_preadders.add_pair2.gen_fa\[3\].fa.a
+ VGND VGND VPWR VPWR _101_ sky130_fd_sc_hd__and2_1
XFILLER_25_93 VPWR VGND VPWR VGND sky130_ef_sc_hd__decap_12
XPHY_EDGE_ROW_22_Left_64 VGND VGND VPWR VPWR sky130_fd_sc_hd__decap_3
XPHY_EDGE_ROW_10_Right_10 VGND VGND VPWR VPWR sky130_fd_sc_hd__decap_3
XFILLER_17_181 VPWR VGND VPWR VGND sky130_ef_sc_hd__decap_12
XTAP_TAPCELL_ROW_19_165 VGND VPWR sky130_fd_sc_hd__tapvpwrvgnd_1
XFILLER_21_18 VPWR VGND VPWR VGND sky130_ef_sc_hd__decap_12
XFILLER_15_129 VGND VGND VPWR VPWR sky130_fd_sc_hd__decap_8
X_318_ symmetric_preadders.add_pair0.gen_fa\[2\].fa.b symmetric_preadders.add_pair0.gen_fa\[2\].fa.a
+ VGND VGND VPWR VPWR _085_ sky130_fd_sc_hd__or2_1
XFILLER_16_18 VGND VGND VPWR VPWR sky130_fd_sc_hd__decap_8
XFILLER_16_29 VPWR VGND VPWR VGND sky130_ef_sc_hd__decap_12
XFILLER_20_132 VGND VGND VPWR VPWR sky130_fd_sc_hd__decap_8
XFILLER_7_169 VPWR VGND VPWR VGND sky130_ef_sc_hd__decap_12
XFILLER_7_125 VPWR VGND VPWR VGND sky130_ef_sc_hd__decap_12
XFILLER_11_154 VGND VGND VPWR VPWR sky130_fd_sc_hd__decap_4
XFILLER_22_83 VGND VGND VPWR VPWR sky130_fd_sc_hd__fill_1
XFILLER_8_85 VPWR VGND VPWR VGND sky130_ef_sc_hd__decap_12
XFILLER_8_41 VPWR VGND VPWR VGND sky130_ef_sc_hd__decap_12
XTAP_TAPCELL_ROW_4_106 VGND VPWR sky130_fd_sc_hd__tapvpwrvgnd_1
XFILLER_27_39 VPWR VGND VPWR VGND sky130_ef_sc_hd__decap_12
XTAP_TAPCELL_ROW_35_230 VGND VPWR sky130_fd_sc_hd__tapvpwrvgnd_1
X_652_ clknet_2_0__leaf_clk _032_ VGND VGND VPWR VPWR symmetric_preadders.add_pair0.gen_fa\[0\].fa.a
+ sky130_fd_sc_hd__dfxtp_1
XFILLER_16_235 VGND VGND VPWR VPWR sky130_fd_sc_hd__fill_2
X_583_ net25 net5 VGND VGND VPWR VPWR _036_ sky130_fd_sc_hd__and2b_1
XTAP_TAPCELL_ROW_41_255 VGND VPWR sky130_fd_sc_hd__tapvpwrvgnd_1
XFILLER_17_94 VPWR VGND VPWR VGND sky130_ef_sc_hd__decap_12
XFILLER_33_93 VPWR VGND VPWR VGND sky130_ef_sc_hd__decap_12
Xhold1 symmetric_preadders.add_pair0.gen_fa\[7\].fa.a VGND VGND VPWR VPWR net29 sky130_fd_sc_hd__dlygate4sd3_1
XPHY_EDGE_ROW_8_Right_8 VGND VGND VPWR VPWR sky130_fd_sc_hd__decap_3
XPHY_EDGE_ROW_39_Right_39 VGND VGND VPWR VPWR sky130_fd_sc_hd__decap_3
XFILLER_38_27 VGND VGND VPWR VPWR sky130_fd_sc_hd__fill_1
XFILLER_0_197 VGND VGND VPWR VPWR sky130_fd_sc_hd__fill_2
X_635_ clknet_2_3__leaf_clk _015_ VGND VGND VPWR VPWR symmetric_preadders.add_pair2.gen_fa\[7\].fa.b
+ sky130_fd_sc_hd__dfxtp_1
X_566_ net24 net52 VGND VGND VPWR VPWR _019_ sky130_fd_sc_hd__and2b_1
XFILLER_28_82 VGND VGND VPWR VPWR sky130_fd_sc_hd__fill_2
X_497_ _155_ _186_ _189_ _226_ _187_ VGND VGND VPWR VPWR _259_ sky130_fd_sc_hd__a311o_1
XFILLER_24_29 VPWR VGND VPWR VGND sky130_ef_sc_hd__decap_12
X_351_ symmetric_preadders.add_pair1.gen_fa\[0\].fa.b symmetric_preadders.add_pair1.gen_fa\[0\].fa.a
+ symmetric_preadders.add_pair1.gen_fa\[1\].fa.b symmetric_preadders.add_pair1.gen_fa\[1\].fa.a
+ VGND VGND VPWR VPWR _117_ sky130_fd_sc_hd__a22o_1
X_420_ _148_ _179_ _181_ _182_ VGND VGND VPWR VPWR _184_ sky130_fd_sc_hd__and4_1
XFILLER_5_223 VGND VGND VPWR VPWR sky130_fd_sc_hd__fill_1
X_618_ _062_ _068_ VGND VGND VPWR VPWR _070_ sky130_fd_sc_hd__nor2_1
X_549_ net23 net56 VGND VGND VPWR VPWR _002_ sky130_fd_sc_hd__and2b_1
XFILLER_27_116 VGND VGND VPWR VPWR sky130_fd_sc_hd__fill_2
XFILLER_35_39 VPWR VGND VPWR VGND sky130_ef_sc_hd__decap_12
XFILLER_35_193 VGND VGND VPWR VPWR sky130_fd_sc_hd__fill_1
XFILLER_41_141 VPWR VGND VPWR VGND sky130_ef_sc_hd__decap_12
X_334_ symmetric_preadders.add_pair2.gen_fa\[3\].fa.b symmetric_preadders.add_pair2.gen_fa\[3\].fa.a
+ VGND VGND VPWR VPWR _100_ sky130_fd_sc_hd__or2_1
X_403_ symmetric_preadders.add_pair2.gen_fa\[5\].fa.b symmetric_preadders.add_pair2.gen_fa\[5\].fa.a
+ VGND VGND VPWR VPWR _167_ sky130_fd_sc_hd__and2_1
XTAP_TAPCELL_ROW_19_166 VGND VPWR sky130_fd_sc_hd__tapvpwrvgnd_1
XFILLER_17_193 VPWR VGND VPWR VGND sky130_ef_sc_hd__decap_12
XFILLER_2_3 VPWR VGND VPWR VGND sky130_ef_sc_hd__decap_12
X_317_ symmetric_preadders.add_pair0.gen_fa\[2\].fa.b symmetric_preadders.add_pair0.gen_fa\[2\].fa.a
+ VGND VGND VPWR VPWR _084_ sky130_fd_sc_hd__nor2_1
XFILLER_14_174 VPWR VGND VPWR VGND sky130_ef_sc_hd__decap_12
XFILLER_36_93 VGND VGND VPWR VPWR sky130_fd_sc_hd__fill_2
XFILLER_35_3 VPWR VGND VPWR VGND sky130_ef_sc_hd__decap_12
XFILLER_37_222 VGND VGND VPWR VPWR sky130_fd_sc_hd__fill_2
XFILLER_32_18 VGND VGND VPWR VPWR sky130_fd_sc_hd__decap_8
XFILLER_32_29 VPWR VGND VPWR VGND sky130_ef_sc_hd__decap_12
Xclkbuf_2_2__f_clk clknet_0_clk VGND VGND VPWR VPWR clknet_2_2__leaf_clk sky130_fd_sc_hd__clkbuf_16
XFILLER_7_137 VPWR VGND VPWR VGND sky130_ef_sc_hd__decap_12
XTAP_TAPCELL_ROW_21_172 VGND VPWR sky130_fd_sc_hd__tapvpwrvgnd_1
XFILLER_19_200 VGND VGND VPWR VPWR sky130_fd_sc_hd__decap_4
XFILLER_8_97 VPWR VGND VPWR VGND sky130_ef_sc_hd__decap_12
XFILLER_8_53 VGND VGND VPWR VPWR sky130_fd_sc_hd__decap_8
XTAP_TAPCELL_ROW_4_107 VGND VPWR sky130_fd_sc_hd__tapvpwrvgnd_1
XFILLER_25_225 VPWR VGND VPWR VGND sky130_ef_sc_hd__decap_12
XTAP_TAPCELL_ROW_35_231 VGND VPWR sky130_fd_sc_hd__tapvpwrvgnd_1
X_651_ clknet_2_2__leaf_clk _031_ VGND VGND VPWR VPWR symmetric_preadders.add_pair1.gen_fa\[7\].fa.a
+ sky130_fd_sc_hd__dfxtp_1
X_582_ net25 net4 VGND VGND VPWR VPWR _035_ sky130_fd_sc_hd__and2b_1
XFILLER_17_51 VGND VGND VPWR VPWR sky130_fd_sc_hd__decap_4
XTAP_TAPCELL_ROW_41_256 VGND VPWR sky130_fd_sc_hd__tapvpwrvgnd_1
XFILLER_33_61 VGND VGND VPWR VPWR sky130_fd_sc_hd__fill_1
Xhold2 symmetric_preadders.add_pair1.gen_fa\[7\].fa.a VGND VGND VPWR VPWR net30 sky130_fd_sc_hd__dlygate4sd3_1
XFILLER_22_217 VPWR VGND VPWR VGND sky130_ef_sc_hd__decap_12
XFILLER_13_206 VPWR VGND VPWR VGND sky130_ef_sc_hd__decap_12
X_634_ clknet_2_3__leaf_clk _014_ VGND VGND VPWR VPWR symmetric_preadders.add_pair2.gen_fa\[6\].fa.b
+ sky130_fd_sc_hd__dfxtp_1
X_565_ net23 net48 VGND VGND VPWR VPWR _018_ sky130_fd_sc_hd__and2b_1
X_496_ _250_ _255_ VGND VGND VPWR VPWR _258_ sky130_fd_sc_hd__xnor2_1
XFILLER_39_125 VGND VGND VPWR VPWR sky130_fd_sc_hd__fill_1
XFILLER_39_158 VGND VGND VPWR VPWR sky130_fd_sc_hd__decap_8
XFILLER_10_209 VPWR VGND VPWR VGND sky130_ef_sc_hd__decap_12
XFILLER_40_29 VPWR VGND VPWR VGND sky130_ef_sc_hd__decap_12
X_350_ _113_ _115_ VGND VGND VPWR VPWR _116_ sky130_fd_sc_hd__nand2_1
XFILLER_14_63 VGND VGND VPWR VPWR sky130_fd_sc_hd__fill_2
XFILLER_14_85 VGND VGND VPWR VPWR sky130_fd_sc_hd__decap_6
XFILLER_14_96 VPWR VGND VPWR VGND sky130_ef_sc_hd__decap_12
XFILLER_30_95 VPWR VGND VPWR VGND sky130_ef_sc_hd__decap_12
X_617_ _062_ _068_ VGND VGND VPWR VPWR _069_ sky130_fd_sc_hd__and2_1
XFILLER_36_117 VGND VGND VPWR VPWR sky130_fd_sc_hd__fill_1
X_548_ net23 net61 VGND VGND VPWR VPWR _001_ sky130_fd_sc_hd__and2b_1
X_479_ _204_ _238_ VGND VGND VPWR VPWR _241_ sky130_fd_sc_hd__xnor2_1
XFILLER_35_172 VGND VGND VPWR VPWR sky130_fd_sc_hd__decap_8
XFILLER_41_197 VGND VGND VPWR VPWR sky130_fd_sc_hd__fill_2
XFILLER_41_153 VGND VGND VPWR VPWR sky130_fd_sc_hd__decap_8
X_333_ _067_ _078_ _079_ VGND VGND VPWR VPWR _099_ sky130_fd_sc_hd__a21bo_1
X_402_ symmetric_preadders.add_pair2.gen_fa\[5\].fa.b symmetric_preadders.add_pair2.gen_fa\[5\].fa.a
+ VGND VGND VPWR VPWR _166_ sky130_fd_sc_hd__or2_2
XFILLER_17_161 VGND VGND VPWR VPWR sky130_fd_sc_hd__decap_6
XTAP_TAPCELL_ROW_19_167 VGND VPWR sky130_fd_sc_hd__tapvpwrvgnd_1
XFILLER_24_109 VGND VGND VPWR VPWR sky130_fd_sc_hd__fill_2
XFILLER_32_186 VGND VGND VPWR VPWR sky130_fd_sc_hd__decap_8
XFILLER_32_197 VPWR VGND VPWR VGND sky130_ef_sc_hd__decap_12
XFILLER_11_53 VGND VGND VPWR VPWR sky130_fd_sc_hd__decap_3
XFILLER_14_131 VGND VGND VPWR VPWR sky130_fd_sc_hd__decap_8
XFILLER_36_83 VGND VGND VPWR VPWR sky130_fd_sc_hd__fill_1
X_316_ _055_ _082_ VGND VGND VPWR VPWR _083_ sky130_fd_sc_hd__xnor2_1
XFILLER_14_186 VGND VGND VPWR VPWR sky130_fd_sc_hd__fill_2
XFILLER_37_245 VGND VGND VPWR VPWR sky130_fd_sc_hd__fill_2
XFILLER_28_3 VPWR VGND VPWR VGND sky130_ef_sc_hd__decap_12
XTAP_TAPCELL_ROW_7_116 VGND VPWR sky130_fd_sc_hd__tapvpwrvgnd_1
XTAP_TAPCELL_ROW_38_240 VGND VPWR sky130_fd_sc_hd__tapvpwrvgnd_1
XFILLER_7_105 VGND VGND VPWR VPWR sky130_fd_sc_hd__decap_6
XFILLER_22_41 VPWR VGND VPWR VGND sky130_ef_sc_hd__decap_12
XFILLER_7_149 VPWR VGND VPWR VGND sky130_ef_sc_hd__decap_12
XTAP_TAPCELL_ROW_21_173 VGND VPWR sky130_fd_sc_hd__tapvpwrvgnd_1
XFILLER_22_85 VGND VGND VPWR VPWR sky130_fd_sc_hd__decap_4
XFILLER_34_204 VGND VGND VPWR VPWR sky130_fd_sc_hd__fill_2
XFILLER_25_237 VGND VGND VPWR VPWR sky130_fd_sc_hd__decap_8
X_650_ clknet_2_2__leaf_clk _030_ VGND VGND VPWR VPWR symmetric_preadders.add_pair1.gen_fa\[6\].fa.a
+ sky130_fd_sc_hd__dfxtp_1
X_581_ net22 net3 VGND VGND VPWR VPWR _034_ sky130_fd_sc_hd__and2b_1
XTAP_TAPCELL_ROW_41_257 VGND VPWR sky130_fd_sc_hd__tapvpwrvgnd_1
XFILLER_33_51 VGND VGND VPWR VPWR sky130_fd_sc_hd__decap_4
XFILLER_33_84 VGND VGND VPWR VPWR sky130_fd_sc_hd__fill_1
XFILLER_3_174 VPWR VGND VPWR VGND sky130_ef_sc_hd__decap_12
XFILLER_3_141 VGND VGND VPWR VPWR sky130_fd_sc_hd__decap_3
Xhold3 symmetric_preadders.add_pair2.gen_fa\[7\].fa.b VGND VGND VPWR VPWR net31 sky130_fd_sc_hd__dlygate4sd3_1
XFILLER_22_229 VGND VGND VPWR VPWR sky130_fd_sc_hd__decap_8
XFILLER_38_29 VPWR VGND VPWR VGND sky130_ef_sc_hd__decap_12
XFILLER_13_218 VGND VGND VPWR VPWR sky130_fd_sc_hd__decap_6
X_633_ clknet_2_3__leaf_clk _013_ VGND VGND VPWR VPWR symmetric_preadders.add_pair2.gen_fa\[5\].fa.b
+ sky130_fd_sc_hd__dfxtp_1
X_564_ net23 net64 VGND VGND VPWR VPWR _017_ sky130_fd_sc_hd__and2b_1
X_495_ _250_ _255_ VGND VGND VPWR VPWR _257_ sky130_fd_sc_hd__and2_1
XFILLER_8_244 VGND VGND VPWR VPWR sky130_fd_sc_hd__decap_3
XFILLER_38_170 VGND VGND VPWR VPWR sky130_fd_sc_hd__decap_8
XFILLER_38_192 VGND VGND VPWR VPWR sky130_fd_sc_hd__decap_4
XFILLER_5_225 VPWR VGND VPWR VGND sky130_ef_sc_hd__decap_12
XFILLER_30_41 VGND VGND VPWR VPWR sky130_fd_sc_hd__decap_6
X_616_ _049_ _065_ _067_ VGND VGND VPWR VPWR _068_ sky130_fd_sc_hd__o21a_1
X_547_ net23 symmetric_preadders.add_pair2.gen_fa\[0\].fa.b VGND VGND VPWR VPWR _000_
+ sky130_fd_sc_hd__and2b_1
XFILLER_29_181 VPWR VGND VPWR VGND sky130_ef_sc_hd__decap_12
XFILLER_36_129 VGND VGND VPWR VPWR sky130_fd_sc_hd__decap_8
X_478_ _204_ _238_ VGND VGND VPWR VPWR _240_ sky130_fd_sc_hd__nor2_1
XFILLER_35_162 VGND VGND VPWR VPWR sky130_fd_sc_hd__fill_2
X_401_ _130_ _131_ _139_ VGND VGND VPWR VPWR _165_ sky130_fd_sc_hd__mux2_1
X_332_ _094_ _097_ _095_ VGND VGND VPWR VPWR _098_ sky130_fd_sc_hd__o21a_1
XFILLER_23_187 VGND VGND VPWR VPWR sky130_fd_sc_hd__fill_1
XFILLER_14_121 VGND VGND VPWR VPWR sky130_fd_sc_hd__decap_3
X_315_ symmetric_preadders.add_pair1.gen_fa\[1\].fa.b symmetric_preadders.add_pair1.gen_fa\[1\].fa.a
+ VGND VGND VPWR VPWR _082_ sky130_fd_sc_hd__xnor2_1
XPHY_EDGE_ROW_26_Left_68 VGND VGND VPWR VPWR sky130_fd_sc_hd__decap_3
XFILLER_37_202 VPWR VGND VPWR VGND sky130_ef_sc_hd__decap_12
XTAP_TAPCELL_ROW_7_117 VGND VPWR sky130_fd_sc_hd__tapvpwrvgnd_1
XTAP_TAPCELL_ROW_38_241 VGND VPWR sky130_fd_sc_hd__tapvpwrvgnd_1
XFILLER_28_246 VGND VGND VPWR VPWR sky130_fd_sc_hd__fill_1
XTAP_TAPCELL_ROW_21_174 VGND VPWR sky130_fd_sc_hd__tapvpwrvgnd_1
XFILLER_22_53 VPWR VGND VPWR VGND sky130_ef_sc_hd__decap_12
XFILLER_6_172 VPWR VGND VPWR VGND sky130_ef_sc_hd__decap_12
XFILLER_40_3 VPWR VGND VPWR VGND sky130_ef_sc_hd__decap_12
XFILLER_25_205 VPWR VGND VPWR VGND sky130_ef_sc_hd__decap_12
X_580_ net22 net2 VGND VGND VPWR VPWR _033_ sky130_fd_sc_hd__and2b_1
XFILLER_16_205 VGND VGND VPWR VPWR sky130_fd_sc_hd__fill_1
XFILLER_31_208 VGND VGND VPWR VPWR sky130_fd_sc_hd__fill_1
XTAP_TAPCELL_ROW_41_258 VGND VPWR sky130_fd_sc_hd__tapvpwrvgnd_1
Xhold4 symmetric_preadders.add_pair2.gen_fa\[7\].fa.a VGND VGND VPWR VPWR net32 sky130_fd_sc_hd__dlygate4sd3_1
XFILLER_3_186 VGND VGND VPWR VPWR sky130_fd_sc_hd__fill_2
XPHY_EDGE_ROW_29_Left_71 VGND VGND VPWR VPWR sky130_fd_sc_hd__decap_3
XPHY_EDGE_ROW_13_Left_55 VGND VGND VPWR VPWR sky130_fd_sc_hd__decap_3
XPHY_EDGE_ROW_17_Right_17 VGND VGND VPWR VPWR sky130_fd_sc_hd__decap_3
XFILLER_0_156 VPWR VGND VPWR VGND sky130_ef_sc_hd__decap_12
XPHY_EDGE_ROW_26_Right_26 VGND VGND VPWR VPWR sky130_fd_sc_hd__decap_3
X_563_ net23 net58 VGND VGND VPWR VPWR _016_ sky130_fd_sc_hd__and2b_1
X_632_ clknet_2_1__leaf_clk _012_ VGND VGND VPWR VPWR symmetric_preadders.add_pair2.gen_fa\[4\].fa.b
+ sky130_fd_sc_hd__dfxtp_1
XFILLER_28_41 VPWR VGND VPWR VGND sky130_ef_sc_hd__decap_12
XFILLER_28_74 VGND VGND VPWR VPWR sky130_fd_sc_hd__decap_8
XFILLER_28_85 VPWR VGND VPWR VGND sky130_ef_sc_hd__decap_12
XFILLER_8_212 VPWR VGND VPWR VGND sky130_ef_sc_hd__decap_12
XFILLER_8_201 VGND VGND VPWR VPWR sky130_fd_sc_hd__fill_1
X_494_ _250_ _255_ VGND VGND VPWR VPWR _256_ sky130_fd_sc_hd__or2_1
XPHY_EDGE_ROW_35_Right_35 VGND VGND VPWR VPWR sky130_fd_sc_hd__decap_3
XFILLER_5_237 VGND VGND VPWR VPWR sky130_fd_sc_hd__decap_6
XFILLER_30_53 VGND VGND VPWR VPWR sky130_fd_sc_hd__fill_1
XFILLER_39_95 VGND VGND VPWR VPWR sky130_fd_sc_hd__decap_6
X_546_ _302_ _303_ VGND VGND VPWR VPWR coefficient_adder.add_final.gen_fa\[11\].fa.sum
+ sky130_fd_sc_hd__xnor2_1
X_615_ _049_ _064_ VGND VGND VPWR VPWR _067_ sky130_fd_sc_hd__nand2_1
XFILLER_29_193 VPWR VGND VPWR VGND sky130_ef_sc_hd__decap_12
X_477_ _204_ _238_ VGND VGND VPWR VPWR _239_ sky130_fd_sc_hd__nand2_1
XFILLER_35_130 VPWR VGND VPWR VGND sky130_ef_sc_hd__decap_12
X_331_ _096_ _097_ VGND VGND VPWR VPWR coefficient_adder.add_final.gen_fa\[3\].fa.sum
+ sky130_fd_sc_hd__xnor2_1
X_400_ _139_ _130_ VGND VGND VPWR VPWR _164_ sky130_fd_sc_hd__and2b_1
XFILLER_41_177 VGND VGND VPWR VPWR sky130_fd_sc_hd__fill_1
XFILLER_41_41 VGND VGND VPWR VPWR sky130_fd_sc_hd__decap_8
XFILLER_41_85 VPWR VGND VPWR VGND sky130_ef_sc_hd__decap_12
XFILLER_2_79 VGND VGND VPWR VPWR sky130_fd_sc_hd__decap_4
XFILLER_32_122 VGND VGND VPWR VPWR sky130_fd_sc_hd__fill_2
XFILLER_32_177 VGND VGND VPWR VPWR sky130_fd_sc_hd__decap_3
X_529_ _287_ _288_ VGND VGND VPWR VPWR _289_ sky130_fd_sc_hd__nand2_1
X_314_ symmetric_preadders.add_pair1.gen_fa\[1\].fa.b symmetric_preadders.add_pair1.gen_fa\[1\].fa.a
+ VGND VGND VPWR VPWR _081_ sky130_fd_sc_hd__or2_1
XPHY_EDGE_ROW_1_Left_43 VGND VGND VPWR VPWR sky130_fd_sc_hd__decap_3
XFILLER_36_41 VPWR VGND VPWR VGND sky130_ef_sc_hd__decap_12
XFILLER_36_85 VGND VGND VPWR VPWR sky130_fd_sc_hd__decap_8
XFILLER_37_214 VGND VGND VPWR VPWR sky130_fd_sc_hd__decap_8
XFILLER_37_225 VPWR VGND VPWR VGND sky130_ef_sc_hd__decap_12
XTAP_TAPCELL_ROW_15_150 VGND VPWR sky130_fd_sc_hd__tapvpwrvgnd_1
XTAP_TAPCELL_ROW_7_118 VGND VPWR sky130_fd_sc_hd__tapvpwrvgnd_1
XTAP_TAPCELL_ROW_38_242 VGND VPWR sky130_fd_sc_hd__tapvpwrvgnd_1
XFILLER_11_103 VGND VGND VPWR VPWR sky130_fd_sc_hd__fill_1
XFILLER_11_169 VGND VGND VPWR VPWR sky130_fd_sc_hd__decap_4
XTAP_TAPCELL_ROW_21_175 VGND VPWR sky130_fd_sc_hd__tapvpwrvgnd_1
XFILLER_22_65 VPWR VGND VPWR VGND sky130_ef_sc_hd__decap_12
XFILLER_0_3 VPWR VGND VPWR VGND sky130_ef_sc_hd__decap_12
XFILLER_19_225 VPWR VGND VPWR VGND sky130_ef_sc_hd__decap_12
XFILLER_6_195 VGND VGND VPWR VPWR sky130_fd_sc_hd__fill_1
XFILLER_6_184 VGND VGND VPWR VPWR sky130_fd_sc_hd__decap_4
XFILLER_33_3 VPWR VGND VPWR VGND sky130_ef_sc_hd__decap_12
XFILLER_25_217 VGND VGND VPWR VPWR sky130_fd_sc_hd__decap_6
XTAP_TAPCELL_ROW_41_259 VGND VPWR sky130_fd_sc_hd__tapvpwrvgnd_1
XFILLER_3_121 VPWR VGND VPWR VGND sky130_ef_sc_hd__decap_12
XFILLER_3_110 VGND VGND VPWR VPWR sky130_fd_sc_hd__fill_2
Xhold5 symmetric_preadders.add_pair1.gen_fa\[7\].fa.b VGND VGND VPWR VPWR net33 sky130_fd_sc_hd__dlygate4sd3_1
XFILLER_22_209 VGND VGND VPWR VPWR sky130_fd_sc_hd__fill_2
X_562_ net27 net32 VGND VGND VPWR VPWR _015_ sky130_fd_sc_hd__and2b_1
X_631_ clknet_2_1__leaf_clk _011_ VGND VGND VPWR VPWR symmetric_preadders.add_pair2.gen_fa\[3\].fa.b
+ sky130_fd_sc_hd__dfxtp_1
XFILLER_28_53 VGND VGND VPWR VPWR sky130_fd_sc_hd__decap_6
XFILLER_28_97 VGND VGND VPWR VPWR sky130_fd_sc_hd__fill_2
X_493_ _253_ _254_ VGND VGND VPWR VPWR _255_ sky130_fd_sc_hd__xor2_1
XFILLER_8_224 VPWR VGND VPWR VGND sky130_ef_sc_hd__decap_12
XPHY_EDGE_ROW_30_Left_72 VGND VGND VPWR VPWR sky130_fd_sc_hd__decap_3
XFILLER_5_68 VGND VGND VPWR VPWR sky130_fd_sc_hd__decap_4
XFILLER_5_57 VGND VGND VPWR VPWR sky130_fd_sc_hd__decap_4
XFILLER_38_161 VGND VGND VPWR VPWR sky130_fd_sc_hd__fill_1
XFILLER_30_76 VGND VGND VPWR VPWR sky130_fd_sc_hd__decap_8
X_545_ _300_ _302_ _301_ VGND VGND VPWR VPWR coefficient_adder.add_final.gen_fa\[11\].fa.cout
+ sky130_fd_sc_hd__a21bo_1
X_614_ _049_ _065_ VGND VGND VPWR VPWR _066_ sky130_fd_sc_hd__and2b_1
X_476_ _236_ _237_ VGND VGND VPWR VPWR _238_ sky130_fd_sc_hd__xor2_1
XFILLER_35_142 VPWR VGND VPWR VGND sky130_ef_sc_hd__decap_12
X_330_ _053_ _070_ _069_ VGND VGND VPWR VPWR _097_ sky130_fd_sc_hd__o21bai_1
XFILLER_25_76 VPWR VGND VPWR VGND sky130_ef_sc_hd__decap_12
XFILLER_26_186 VGND VGND VPWR VPWR sky130_fd_sc_hd__decap_4
XFILLER_41_97 VPWR VGND VPWR VGND sky130_ef_sc_hd__decap_12
X_459_ _220_ _221_ _173_ VGND VGND VPWR VPWR _222_ sky130_fd_sc_hd__nand3b_1
X_528_ _277_ _279_ _276_ VGND VGND VPWR VPWR _288_ sky130_fd_sc_hd__a21o_1
XFILLER_23_167 VGND VGND VPWR VPWR sky130_fd_sc_hd__fill_1
XFILLER_36_53 VPWR VGND VPWR VGND sky130_ef_sc_hd__decap_12
X_313_ _066_ _078_ VGND VGND VPWR VPWR _080_ sky130_fd_sc_hd__xnor2_1
XFILLER_14_112 VGND VGND VPWR VPWR sky130_fd_sc_hd__fill_1
XTAP_TAPCELL_ROW_24_184 VGND VPWR sky130_fd_sc_hd__tapvpwrvgnd_1
Xfir_filter_top_28 VGND VGND VPWR VPWR fir_filter_top_28/HI data_out[0] sky130_fd_sc_hd__conb_1
XFILLER_37_237 VGND VGND VPWR VPWR sky130_fd_sc_hd__decap_8
XTAP_TAPCELL_ROW_15_151 VGND VPWR sky130_fd_sc_hd__tapvpwrvgnd_1
XTAP_TAPCELL_ROW_7_119 VGND VPWR sky130_fd_sc_hd__tapvpwrvgnd_1
XTAP_TAPCELL_ROW_38_243 VGND VPWR sky130_fd_sc_hd__tapvpwrvgnd_1
XFILLER_22_77 VGND VGND VPWR VPWR sky130_fd_sc_hd__decap_6
XFILLER_19_204 VGND VGND VPWR VPWR sky130_fd_sc_hd__fill_1
XFILLER_19_237 VGND VGND VPWR VPWR sky130_fd_sc_hd__decap_6
XFILLER_6_141 VPWR VGND VPWR VGND sky130_ef_sc_hd__decap_12
XFILLER_10_181 VGND VGND VPWR VPWR sky130_fd_sc_hd__decap_3
XFILLER_10_192 VGND VGND VPWR VPWR sky130_fd_sc_hd__decap_4
XFILLER_26_3 VPWR VGND VPWR VGND sky130_ef_sc_hd__decap_12
XTAP_TAPCELL_ROW_3_100 VGND VPWR sky130_fd_sc_hd__tapvpwrvgnd_1
XFILLER_17_55 VGND VGND VPWR VPWR sky130_fd_sc_hd__fill_1
XFILLER_3_166 VGND VGND VPWR VPWR sky130_fd_sc_hd__fill_2
XFILLER_3_133 VGND VGND VPWR VPWR sky130_fd_sc_hd__decap_8
Xhold6 symmetric_preadders.add_pair2.gen_fa\[3\].fa.b VGND VGND VPWR VPWR net34 sky130_fd_sc_hd__dlygate4sd3_1
XFILLER_30_221 VPWR VGND VPWR VGND sky130_ef_sc_hd__decap_12
XTAP_TAPCELL_ROW_32_216 VGND VPWR sky130_fd_sc_hd__tapvpwrvgnd_1
XPHY_EDGE_ROW_3_Right_3 VGND VGND VPWR VPWR sky130_fd_sc_hd__decap_3
XFILLER_0_169 VPWR VGND VPWR VGND sky130_ef_sc_hd__decap_12
X_630_ clknet_2_1__leaf_clk _010_ VGND VGND VPWR VPWR symmetric_preadders.add_pair2.gen_fa\[2\].fa.b
+ sky130_fd_sc_hd__dfxtp_1
XFILLER_12_221 VPWR VGND VPWR VGND sky130_ef_sc_hd__decap_12
X_492_ _173_ _217_ _221_ _218_ VGND VGND VPWR VPWR _254_ sky130_fd_sc_hd__a31o_1
X_561_ net27 net35 VGND VGND VPWR VPWR _014_ sky130_fd_sc_hd__and2b_1
XFILLER_8_236 VGND VGND VPWR VPWR sky130_fd_sc_hd__decap_8
XFILLER_10_6 VPWR VGND VPWR VGND sky130_ef_sc_hd__decap_12
X_613_ _048_ _064_ VGND VGND VPWR VPWR _065_ sky130_fd_sc_hd__xnor2_1
X_544_ _300_ _301_ VGND VGND VPWR VPWR _303_ sky130_fd_sc_hd__nand2_1
X_475_ _166_ _197_ _201_ _198_ VGND VGND VPWR VPWR _237_ sky130_fd_sc_hd__a31oi_4
XFILLER_35_121 VGND VGND VPWR VPWR sky130_fd_sc_hd__fill_2
XFILLER_35_154 VGND VGND VPWR VPWR sky130_fd_sc_hd__decap_8
XFILLER_2_209 VPWR VGND VPWR VGND sky130_ef_sc_hd__decap_12
XFILLER_41_113 VPWR VGND VPWR VGND sky130_ef_sc_hd__decap_12
XFILLER_26_176 VGND VGND VPWR VPWR sky130_fd_sc_hd__decap_4
XFILLER_2_15 VPWR VGND VPWR VGND sky130_ef_sc_hd__decap_12
XFILLER_2_37 VGND VGND VPWR VPWR sky130_fd_sc_hd__fill_2
X_527_ _271_ _274_ _272_ VGND VGND VPWR VPWR _287_ sky130_fd_sc_hd__a21bo_1
X_389_ _146_ _147_ _153_ VGND VGND VPWR VPWR _154_ sky130_fd_sc_hd__and3_1
X_458_ _107_ _142_ _145_ _174_ _143_ VGND VGND VPWR VPWR _221_ sky130_fd_sc_hd__a311o_1
XFILLER_32_157 VPWR VGND VPWR VGND sky130_ef_sc_hd__decap_12
XTAP_TAPCELL_ROW_18_160 VGND VPWR sky130_fd_sc_hd__tapvpwrvgnd_1
XFILLER_23_102 VGND VGND VPWR VPWR sky130_fd_sc_hd__decap_3
XFILLER_11_57 VGND VGND VPWR VPWR sky130_fd_sc_hd__decap_6
XFILLER_36_65 VPWR VGND VPWR VGND sky130_ef_sc_hd__decap_12
X_312_ _076_ _077_ _065_ VGND VGND VPWR VPWR _079_ sky130_fd_sc_hd__a21bo_1
XTAP_TAPCELL_ROW_24_185 VGND VPWR sky130_fd_sc_hd__tapvpwrvgnd_1
XFILLER_28_216 VPWR VGND VPWR VGND sky130_ef_sc_hd__decap_12
XFILLER_19_216 VGND VGND VPWR VPWR sky130_fd_sc_hd__decap_8
XFILLER_6_153 VPWR VGND VPWR VGND sky130_ef_sc_hd__decap_12
XFILLER_6_131 VGND VGND VPWR VPWR sky130_fd_sc_hd__decap_8
XFILLER_6_197 VPWR VGND VPWR VGND sky130_ef_sc_hd__decap_12
XFILLER_19_3 VPWR VGND VPWR VGND sky130_ef_sc_hd__decap_12
XTAP_TAPCELL_ROW_3_101 VGND VPWR sky130_fd_sc_hd__tapvpwrvgnd_1
XFILLER_17_89 VGND VGND VPWR VPWR sky130_fd_sc_hd__fill_2
XFILLER_33_55 VGND VGND VPWR VPWR sky130_fd_sc_hd__fill_1
XFILLER_33_66 VPWR VGND VPWR VGND sky130_ef_sc_hd__decap_12
Xhold7 symmetric_preadders.add_pair2.gen_fa\[6\].fa.a VGND VGND VPWR VPWR net35 sky130_fd_sc_hd__dlygate4sd3_1
XFILLER_30_233 VPWR VGND VPWR VGND sky130_ef_sc_hd__decap_12
XTAP_TAPCELL_ROW_32_217 VGND VPWR sky130_fd_sc_hd__tapvpwrvgnd_1
XTAP_TAPCELL_ROW_40_250 VGND VPWR sky130_fd_sc_hd__tapvpwrvgnd_1
XFILLER_0_81 VGND VGND VPWR VPWR sky130_fd_sc_hd__decap_3
XFILLER_21_200 VGND VGND VPWR VPWR sky130_fd_sc_hd__decap_4
X_560_ net27 net41 VGND VGND VPWR VPWR _013_ sky130_fd_sc_hd__and2b_1
XFILLER_12_233 VPWR VGND VPWR VGND sky130_ef_sc_hd__decap_12
X_491_ _251_ _252_ VGND VGND VPWR VPWR _253_ sky130_fd_sc_hd__nand2_1
XFILLER_39_119 VGND VGND VPWR VPWR sky130_fd_sc_hd__decap_6
XPHY_EDGE_ROW_13_Right_13 VGND VGND VPWR VPWR sky130_fd_sc_hd__decap_3
XPHY_EDGE_ROW_17_Left_59 VGND VGND VPWR VPWR sky130_fd_sc_hd__decap_3
XPHY_EDGE_ROW_22_Right_22 VGND VGND VPWR VPWR sky130_fd_sc_hd__decap_3
XPHY_EDGE_ROW_31_Right_31 VGND VGND VPWR VPWR sky130_fd_sc_hd__decap_3
XPHY_EDGE_ROW_40_Right_40 VGND VGND VPWR VPWR sky130_fd_sc_hd__decap_3
XFILLER_14_46 VGND VGND VPWR VPWR sky130_fd_sc_hd__decap_6
X_543_ _296_ _299_ _297_ VGND VGND VPWR VPWR _302_ sky130_fd_sc_hd__o21a_1
X_612_ symmetric_preadders.add_pair2.gen_fa\[1\].fa.b symmetric_preadders.add_pair2.gen_fa\[1\].fa.a
+ VGND VGND VPWR VPWR _064_ sky130_fd_sc_hd__xor2_1
XFILLER_29_163 VGND VGND VPWR VPWR sky130_fd_sc_hd__decap_4
X_474_ _234_ _235_ VGND VGND VPWR VPWR _236_ sky130_fd_sc_hd__nand2_1
XFILLER_35_111 VGND VGND VPWR VPWR sky130_fd_sc_hd__fill_1
XFILLER_41_169 VGND VGND VPWR VPWR sky130_fd_sc_hd__decap_8
XFILLER_41_125 VPWR VGND VPWR VGND sky130_ef_sc_hd__decap_12
XFILLER_41_55 VGND VGND VPWR VPWR sky130_fd_sc_hd__fill_1
XFILLER_2_27 VGND VGND VPWR VPWR sky130_fd_sc_hd__fill_1
X_526_ _284_ _286_ VGND VGND VPWR VPWR coefficient_adder.add_final.gen_fa\[9\].fa.sum
+ sky130_fd_sc_hd__xor2_1
X_388_ _151_ _152_ VGND VGND VPWR VPWR _153_ sky130_fd_sc_hd__xnor2_1
X_457_ _217_ _219_ VGND VGND VPWR VPWR _220_ sky130_fd_sc_hd__nand2_1
XFILLER_32_169 VGND VGND VPWR VPWR sky130_fd_sc_hd__decap_8
XTAP_TAPCELL_ROW_18_161 VGND VPWR sky130_fd_sc_hd__tapvpwrvgnd_1
XFILLER_23_125 VPWR VGND VPWR VGND sky130_ef_sc_hd__decap_12
XFILLER_23_169 VPWR VGND VPWR VGND sky130_ef_sc_hd__decap_12
XFILLER_36_77 VGND VGND VPWR VPWR sky130_fd_sc_hd__decap_6
X_311_ _076_ _077_ VGND VGND VPWR VPWR _078_ sky130_fd_sc_hd__and2_1
XTAP_TAPCELL_ROW_24_186 VGND VPWR sky130_fd_sc_hd__tapvpwrvgnd_1
X_509_ _251_ _254_ VGND VGND VPWR VPWR _270_ sky130_fd_sc_hd__nand2_1
XFILLER_28_228 VPWR VGND VPWR VGND sky130_ef_sc_hd__decap_12
XPHY_EDGE_ROW_5_Left_47 VGND VGND VPWR VPWR sky130_fd_sc_hd__decap_3
XFILLER_8_15 VPWR VGND VPWR VGND sky130_ef_sc_hd__decap_12
XFILLER_34_209 VPWR VGND VPWR VGND sky130_ef_sc_hd__decap_12
XFILLER_6_165 VGND VGND VPWR VPWR sky130_fd_sc_hd__fill_2
XTAP_TAPCELL_ROW_3_102 VGND VPWR sky130_fd_sc_hd__tapvpwrvgnd_1
XFILLER_17_57 VPWR VGND VPWR VGND sky130_ef_sc_hd__decap_12
XFILLER_33_78 VGND VGND VPWR VPWR sky130_fd_sc_hd__decap_6
XFILLER_3_113 VGND VGND VPWR VPWR sky130_fd_sc_hd__decap_3
Xhold8 symmetric_preadders.add_pair2.gen_fa\[5\].fa.b VGND VGND VPWR VPWR net36 sky130_fd_sc_hd__dlygate4sd3_1
XTAP_TAPCELL_ROW_40_251 VGND VPWR sky130_fd_sc_hd__tapvpwrvgnd_1
XFILLER_30_201 VGND VGND VPWR VPWR sky130_fd_sc_hd__fill_1
XFILLER_30_212 VGND VGND VPWR VPWR sky130_fd_sc_hd__fill_2
XFILLER_30_245 VGND VGND VPWR VPWR sky130_fd_sc_hd__fill_2
XTAP_TAPCELL_ROW_32_218 VGND VPWR sky130_fd_sc_hd__tapvpwrvgnd_1
XFILLER_31_3 VPWR VGND VPWR VGND sky130_ef_sc_hd__decap_12
XFILLER_21_245 VGND VGND VPWR VPWR sky130_fd_sc_hd__fill_2
XFILLER_0_127 VPWR VGND VPWR VGND sky130_ef_sc_hd__decap_12
XFILLER_0_149 VGND VGND VPWR VPWR sky130_fd_sc_hd__fill_1
XFILLER_12_245 VGND VGND VPWR VPWR sky130_fd_sc_hd__fill_2
X_490_ symmetric_preadders.add_pair0.gen_fa\[7\].fa.b symmetric_preadders.add_pair0.gen_fa\[7\].fa.a
+ VGND VGND VPWR VPWR _252_ sky130_fd_sc_hd__nand2_1
XPHY_EDGE_ROW_8_Left_50 VGND VGND VPWR VPWR sky130_fd_sc_hd__decap_3
Xclkbuf_2_3__f_clk clknet_0_clk VGND VGND VPWR VPWR clknet_2_3__leaf_clk sky130_fd_sc_hd__clkbuf_16
XFILLER_38_197 VPWR VGND VPWR VGND sky130_ef_sc_hd__decap_12
XFILLER_39_77 VGND VGND VPWR VPWR sky130_fd_sc_hd__decap_4
X_542_ _289_ _295_ VGND VGND VPWR VPWR _301_ sky130_fd_sc_hd__or2_1
X_611_ symmetric_preadders.add_pair2.gen_fa\[1\].fa.b symmetric_preadders.add_pair2.gen_fa\[1\].fa.a
+ VGND VGND VPWR VPWR _063_ sky130_fd_sc_hd__or2_1
XPHY_EDGE_ROW_34_Left_76 VGND VGND VPWR VPWR sky130_fd_sc_hd__decap_3
X_473_ symmetric_preadders.add_pair2.gen_fa\[7\].fa.b symmetric_preadders.add_pair2.gen_fa\[7\].fa.a
+ VGND VGND VPWR VPWR _235_ sky130_fd_sc_hd__nand2_1
XFILLER_35_167 VGND VGND VPWR VPWR sky130_fd_sc_hd__fill_1
XFILLER_35_189 VGND VGND VPWR VPWR sky130_fd_sc_hd__decap_4
XFILLER_41_137 VGND VGND VPWR VPWR sky130_fd_sc_hd__decap_3
XFILLER_9_3 VPWR VGND VPWR VGND sky130_ef_sc_hd__decap_12
XFILLER_1_211 VPWR VGND VPWR VGND sky130_ef_sc_hd__decap_12
XFILLER_17_167 VGND VGND VPWR VPWR sky130_fd_sc_hd__fill_1
X_456_ symmetric_preadders.add_pair0.gen_fa\[6\].fa.b symmetric_preadders.add_pair0.gen_fa\[6\].fa.a
+ VGND VGND VPWR VPWR _219_ sky130_fd_sc_hd__nand2_1
X_525_ _262_ _285_ VGND VGND VPWR VPWR _286_ sky130_fd_sc_hd__nand2_1
X_387_ _081_ _113_ _117_ _114_ VGND VGND VPWR VPWR _152_ sky130_fd_sc_hd__a31o_1
XTAP_TAPCELL_ROW_18_162 VGND VPWR sky130_fd_sc_hd__tapvpwrvgnd_1
XFILLER_23_137 VPWR VGND VPWR VGND sky130_ef_sc_hd__decap_12
XFILLER_31_192 VGND VGND VPWR VPWR sky130_fd_sc_hd__decap_4
XFILLER_11_15 VPWR VGND VPWR VGND sky130_ef_sc_hd__decap_12
X_310_ _063_ _075_ _074_ VGND VGND VPWR VPWR _077_ sky130_fd_sc_hd__a21o_1
XTAP_TAPCELL_ROW_24_187 VGND VPWR sky130_fd_sc_hd__tapvpwrvgnd_1
XFILLER_13_181 VGND VGND VPWR VPWR sky130_fd_sc_hd__decap_6
X_439_ _166_ _200_ _201_ VGND VGND VPWR VPWR _202_ sky130_fd_sc_hd__nand3_1
X_508_ _267_ _268_ VGND VGND VPWR VPWR _269_ sky130_fd_sc_hd__xnor2_1
XFILLER_9_163 VGND VGND VPWR VPWR sky130_fd_sc_hd__decap_4
XPHY_EDGE_ROW_21_Left_63 VGND VGND VPWR VPWR sky130_fd_sc_hd__decap_3
XFILLER_11_118 VGND VGND VPWR VPWR sky130_fd_sc_hd__fill_2
XFILLER_27_240 VGND VGND VPWR VPWR sky130_fd_sc_hd__decap_3
XFILLER_8_27 VGND VGND VPWR VPWR sky130_fd_sc_hd__fill_1
XFILLER_6_188 VGND VGND VPWR VPWR sky130_fd_sc_hd__fill_1
XFILLER_18_240 VGND VGND VPWR VPWR sky130_fd_sc_hd__decap_6
XTAP_TAPCELL_ROW_3_103 VGND VPWR sky130_fd_sc_hd__tapvpwrvgnd_1
XFILLER_17_69 VPWR VGND VPWR VGND sky130_ef_sc_hd__decap_12
XFILLER_24_221 VPWR VGND VPWR VGND sky130_ef_sc_hd__decap_12
XFILLER_33_57 VGND VGND VPWR VPWR sky130_fd_sc_hd__decap_4
XFILLER_3_169 VGND VGND VPWR VPWR sky130_fd_sc_hd__fill_2
XFILLER_3_158 VGND VGND VPWR VPWR sky130_fd_sc_hd__decap_8
Xhold9 symmetric_preadders.add_pair2.gen_fa\[3\].fa.a VGND VGND VPWR VPWR net37 sky130_fd_sc_hd__dlygate4sd3_1
XTAP_TAPCELL_ROW_32_219 VGND VPWR sky130_fd_sc_hd__tapvpwrvgnd_1
XFILLER_24_3 VPWR VGND VPWR VGND sky130_ef_sc_hd__decap_12
XFILLER_0_139 VGND VGND VPWR VPWR sky130_fd_sc_hd__fill_1
XPHY_EDGE_ROW_7_Right_7 VGND VGND VPWR VPWR sky130_fd_sc_hd__decap_3
XFILLER_14_15 VPWR VGND VPWR VGND sky130_ef_sc_hd__decap_12
X_610_ _057_ _060_ VGND VGND VPWR VPWR _062_ sky130_fd_sc_hd__xor2_1
X_541_ _289_ _295_ VGND VGND VPWR VPWR _300_ sky130_fd_sc_hd__nand2_1
X_472_ symmetric_preadders.add_pair2.gen_fa\[7\].fa.b symmetric_preadders.add_pair2.gen_fa\[7\].fa.a
+ VGND VGND VPWR VPWR _234_ sky130_fd_sc_hd__or2_1
XFILLER_35_113 VGND VGND VPWR VPWR sky130_fd_sc_hd__decap_8
XFILLER_41_57 VPWR VGND VPWR VGND sky130_ef_sc_hd__decap_12
XFILLER_1_223 VGND VGND VPWR VPWR sky130_fd_sc_hd__fill_1
XFILLER_1_245 VGND VGND VPWR VPWR sky130_fd_sc_hd__fill_2
XFILLER_2_29 VGND VGND VPWR VPWR sky130_fd_sc_hd__decap_8
XFILLER_17_113 VPWR VGND VPWR VGND sky130_ef_sc_hd__decap_12
X_386_ _148_ _150_ VGND VGND VPWR VPWR _151_ sky130_fd_sc_hd__nand2_1
XTAP_TAPCELL_ROW_27_196 VGND VPWR sky130_fd_sc_hd__tapvpwrvgnd_1
X_455_ symmetric_preadders.add_pair0.gen_fa\[6\].fa.b symmetric_preadders.add_pair0.gen_fa\[6\].fa.a
+ VGND VGND VPWR VPWR _218_ sky130_fd_sc_hd__and2_1
X_524_ _231_ _233_ _263_ _230_ VGND VGND VPWR VPWR _285_ sky130_fd_sc_hd__a211o_1
XFILLER_40_182 VPWR VGND VPWR VGND sky130_ef_sc_hd__decap_12
XTAP_TAPCELL_ROW_18_163 VGND VPWR sky130_fd_sc_hd__tapvpwrvgnd_1
XFILLER_23_149 VPWR VGND VPWR VGND sky130_ef_sc_hd__decap_12
XFILLER_11_27 VPWR VGND VPWR VGND sky130_ef_sc_hd__decap_12
XFILLER_20_108 VPWR VGND VPWR VGND sky130_ef_sc_hd__decap_12
X_369_ symmetric_preadders.add_pair2.gen_fa\[4\].fa.b symmetric_preadders.add_pair2.gen_fa\[4\].fa.a
+ VGND VGND VPWR VPWR _134_ sky130_fd_sc_hd__or2_1
X_438_ _100_ _134_ _136_ _167_ _135_ VGND VGND VPWR VPWR _201_ sky130_fd_sc_hd__a311o_2
X_507_ _239_ _242_ _240_ VGND VGND VPWR VPWR _268_ sky130_fd_sc_hd__a21o_1
XFILLER_9_186 VGND VGND VPWR VPWR sky130_fd_sc_hd__fill_1
XFILLER_36_230 VPWR VGND VPWR VGND sky130_ef_sc_hd__decap_12
XFILLER_22_15 VPWR VGND VPWR VGND sky130_ef_sc_hd__decap_12
XTAP_TAPCELL_ROW_6_112 VGND VPWR sky130_fd_sc_hd__tapvpwrvgnd_1
XTAP_TAPCELL_ROW_12_136 VGND VPWR sky130_fd_sc_hd__tapvpwrvgnd_1
XFILLER_33_200 VPWR VGND VPWR VGND sky130_ef_sc_hd__decap_12
XTAP_TAPCELL_ROW_35_228 VGND VPWR sky130_fd_sc_hd__tapvpwrvgnd_1
XFILLER_17_15 VPWR VGND VPWR VGND sky130_ef_sc_hd__decap_12
XFILLER_24_233 VPWR VGND VPWR VGND sky130_ef_sc_hd__decap_12
XFILLER_17_3 VPWR VGND VPWR VGND sky130_ef_sc_hd__decap_12
XFILLER_21_225 VPWR VGND VPWR VGND sky130_ef_sc_hd__decap_12
XFILLER_5_18 VPWR VGND VPWR VGND sky130_ef_sc_hd__decap_12
XFILLER_38_133 VGND VGND VPWR VPWR sky130_fd_sc_hd__fill_1
XFILLER_14_27 VGND VGND VPWR VPWR sky130_fd_sc_hd__fill_1
XFILLER_30_15 VPWR VGND VPWR VGND sky130_ef_sc_hd__decap_12
XFILLER_30_59 VGND VGND VPWR VPWR sky130_fd_sc_hd__fill_1
X_540_ _298_ _299_ VGND VGND VPWR VPWR coefficient_adder.add_final.gen_fa\[10\].fa.sum
+ sky130_fd_sc_hd__xnor2_1
XFILLER_39_57 VGND VGND VPWR VPWR sky130_fd_sc_hd__decap_4
XFILLER_29_111 VGND VGND VPWR VPWR sky130_fd_sc_hd__fill_1
X_471_ _232_ _233_ VGND VGND VPWR VPWR coefficient_adder.add_final.gen_fa\[7\].fa.sum
+ sky130_fd_sc_hd__xnor2_1
X_669_ coefficient_adder.add_final.gen_fa\[1\].fa.sum VGND VGND VPWR VPWR net13 sky130_fd_sc_hd__clkbuf_1
XFILLER_6_83 VGND VGND VPWR VPWR sky130_fd_sc_hd__fill_1
XFILLER_26_103 VPWR VGND VPWR VGND sky130_ef_sc_hd__decap_12
XFILLER_26_136 VGND VGND VPWR VPWR sky130_fd_sc_hd__decap_4
XFILLER_41_69 VPWR VGND VPWR VGND sky130_ef_sc_hd__decap_12
XFILLER_17_125 VPWR VGND VPWR VGND sky130_ef_sc_hd__decap_12
XFILLER_17_169 VPWR VGND VPWR VGND sky130_ef_sc_hd__decap_12
X_523_ _281_ _283_ VGND VGND VPWR VPWR _284_ sky130_fd_sc_hd__nand2_1
XFILLER_40_194 VGND VGND VPWR VPWR sky130_fd_sc_hd__fill_2
XFILLER_15_81 VGND VGND VPWR VPWR sky130_fd_sc_hd__decap_4
X_385_ symmetric_preadders.add_pair1.gen_fa\[3\].fa.b symmetric_preadders.add_pair1.gen_fa\[3\].fa.a
+ VGND VGND VPWR VPWR _150_ sky130_fd_sc_hd__nand2_1
XTAP_TAPCELL_ROW_27_197 VGND VPWR sky130_fd_sc_hd__tapvpwrvgnd_1
X_454_ symmetric_preadders.add_pair0.gen_fa\[6\].fa.b symmetric_preadders.add_pair0.gen_fa\[6\].fa.a
+ VGND VGND VPWR VPWR _217_ sky130_fd_sc_hd__or2_1
XFILLER_11_39 VGND VGND VPWR VPWR sky130_fd_sc_hd__decap_8
XFILLER_31_161 VGND VGND VPWR VPWR sky130_fd_sc_hd__decap_6
XFILLER_14_139 VGND VGND VPWR VPWR sky130_fd_sc_hd__fill_1
XFILLER_22_194 VGND VGND VPWR VPWR sky130_fd_sc_hd__fill_2
X_506_ _235_ _234_ _237_ VGND VGND VPWR VPWR _267_ sky130_fd_sc_hd__mux2_1
XFILLER_9_110 VGND VGND VPWR VPWR sky130_fd_sc_hd__fill_2
XFILLER_13_150 VPWR VGND VPWR VGND sky130_ef_sc_hd__decap_12
XFILLER_13_194 VPWR VGND VPWR VGND sky130_ef_sc_hd__decap_12
X_368_ symmetric_preadders.add_pair2.gen_fa\[4\].fa.b symmetric_preadders.add_pair2.gen_fa\[4\].fa.a
+ VGND VGND VPWR VPWR _133_ sky130_fd_sc_hd__nor2_1
X_437_ _197_ _199_ VGND VGND VPWR VPWR _200_ sky130_fd_sc_hd__nand2_1
XFILLER_3_51 VGND VGND VPWR VPWR sky130_fd_sc_hd__decap_4
XFILLER_28_209 VGND VGND VPWR VPWR sky130_fd_sc_hd__fill_2
XFILLER_36_242 VGND VGND VPWR VPWR sky130_fd_sc_hd__fill_1
XFILLER_22_27 VGND VGND VPWR VPWR sky130_fd_sc_hd__fill_1
XTAP_TAPCELL_ROW_6_113 VGND VPWR sky130_fd_sc_hd__tapvpwrvgnd_1
XTAP_TAPCELL_ROW_29_204 VGND VPWR sky130_fd_sc_hd__tapvpwrvgnd_1
XPHY_EDGE_ROW_29_Right_29 VGND VGND VPWR VPWR sky130_fd_sc_hd__decap_3
XPHY_EDGE_ROW_38_Right_38 VGND VGND VPWR VPWR sky130_fd_sc_hd__decap_3
XFILLER_8_29 VPWR VGND VPWR VGND sky130_ef_sc_hd__decap_12
XTAP_TAPCELL_ROW_12_137 VGND VPWR sky130_fd_sc_hd__tapvpwrvgnd_1
XFILLER_10_197 VPWR VGND VPWR VGND sky130_ef_sc_hd__decap_12
XTAP_TAPCELL_ROW_20_170 VGND VPWR sky130_fd_sc_hd__tapvpwrvgnd_1
XFILLER_33_212 VPWR VGND VPWR VGND sky130_ef_sc_hd__decap_12
XFILLER_33_245 VGND VGND VPWR VPWR sky130_fd_sc_hd__fill_2
XTAP_TAPCELL_ROW_35_229 VGND VPWR sky130_fd_sc_hd__tapvpwrvgnd_1
XFILLER_17_27 VPWR VGND VPWR VGND sky130_ef_sc_hd__decap_12
XFILLER_24_245 VGND VGND VPWR VPWR sky130_fd_sc_hd__fill_2
XFILLER_33_15 VPWR VGND VPWR VGND sky130_ef_sc_hd__decap_12
XFILLER_15_223 VGND VGND VPWR VPWR sky130_fd_sc_hd__fill_1
XFILLER_15_245 VGND VGND VPWR VPWR sky130_fd_sc_hd__fill_2
XFILLER_2_182 VPWR VGND VPWR VGND sky130_ef_sc_hd__decap_12
XFILLER_0_41 VGND VGND VPWR VPWR sky130_fd_sc_hd__decap_4
XFILLER_0_85 VPWR VGND VPWR VGND sky130_ef_sc_hd__decap_12
XFILLER_21_215 VGND VGND VPWR VPWR sky130_fd_sc_hd__fill_2
XFILLER_21_237 VGND VGND VPWR VPWR sky130_fd_sc_hd__decap_8
XFILLER_28_15 VPWR VGND VPWR VGND sky130_ef_sc_hd__decap_12
XFILLER_28_59 VGND VGND VPWR VPWR sky130_fd_sc_hd__fill_1
XFILLER_38_101 VGND VGND VPWR VPWR sky130_fd_sc_hd__fill_1
XFILLER_38_178 VGND VGND VPWR VPWR sky130_fd_sc_hd__decap_3
XFILLER_30_27 VGND VGND VPWR VPWR sky130_fd_sc_hd__fill_1
XFILLER_39_47 VGND VGND VPWR VPWR sky130_fd_sc_hd__decap_3
XFILLER_29_167 VGND VGND VPWR VPWR sky130_fd_sc_hd__fill_1
X_470_ _161_ _192_ _195_ _193_ VGND VGND VPWR VPWR _233_ sky130_fd_sc_hd__o31a_1
XFILLER_4_222 VGND VGND VPWR VPWR sky130_fd_sc_hd__fill_2
XFILLER_20_82 VGND VGND VPWR VPWR sky130_fd_sc_hd__fill_2
X_599_ _050_ _051_ VGND VGND VPWR VPWR _052_ sky130_fd_sc_hd__and2_1
XFILLER_26_115 VGND VGND VPWR VPWR sky130_fd_sc_hd__decap_4
XFILLER_41_15 VPWR VGND VPWR VGND sky130_ef_sc_hd__decap_12
XFILLER_1_225 VPWR VGND VPWR VGND sky130_ef_sc_hd__decap_12
XFILLER_17_137 VPWR VGND VPWR VGND sky130_ef_sc_hd__decap_12
X_453_ _214_ _215_ VGND VGND VPWR VPWR _216_ sky130_fd_sc_hd__xnor2_1
XFILLER_32_107 VGND VGND VPWR VPWR sky130_fd_sc_hd__decap_3
X_522_ _269_ _280_ VGND VGND VPWR VPWR _283_ sky130_fd_sc_hd__nand2_1
X_384_ symmetric_preadders.add_pair1.gen_fa\[3\].fa.b symmetric_preadders.add_pair1.gen_fa\[3\].fa.a
+ VGND VGND VPWR VPWR _149_ sky130_fd_sc_hd__and2_1
XFILLER_25_181 VPWR VGND VPWR VGND sky130_ef_sc_hd__decap_12
XTAP_TAPCELL_ROW_27_198 VGND VPWR sky130_fd_sc_hd__tapvpwrvgnd_1
XTAP_TAPCELL_ROW_2_96 VGND VPWR sky130_fd_sc_hd__tapvpwrvgnd_1
XFILLER_16_181 VPWR VGND VPWR VGND sky130_ef_sc_hd__decap_12
XFILLER_31_140 VGND VGND VPWR VPWR sky130_fd_sc_hd__fill_2
XFILLER_31_173 VGND VGND VPWR VPWR sky130_fd_sc_hd__fill_1
XFILLER_31_184 VGND VGND VPWR VPWR sky130_fd_sc_hd__fill_1
XFILLER_36_15 VPWR VGND VPWR VGND sky130_ef_sc_hd__decap_12
XFILLER_7_3 VPWR VGND VPWR VGND sky130_ef_sc_hd__decap_12
X_436_ symmetric_preadders.add_pair2.gen_fa\[6\].fa.b symmetric_preadders.add_pair2.gen_fa\[6\].fa.a
+ VGND VGND VPWR VPWR _199_ sky130_fd_sc_hd__nand2_1
X_505_ _265_ _266_ VGND VGND VPWR VPWR coefficient_adder.add_final.gen_fa\[8\].fa.sum
+ sky130_fd_sc_hd__xnor2_1
XFILLER_13_162 VGND VGND VPWR VPWR sky130_fd_sc_hd__decap_6
X_367_ _130_ _131_ VGND VGND VPWR VPWR _132_ sky130_fd_sc_hd__nand2_1
XTAP_TAPCELL_ROW_6_114 VGND VPWR sky130_fd_sc_hd__tapvpwrvgnd_1
XTAP_TAPCELL_ROW_29_205 VGND VPWR sky130_fd_sc_hd__tapvpwrvgnd_1
XFILLER_27_221 VGND VGND VPWR VPWR sky130_fd_sc_hd__decap_3
XFILLER_6_103 VPWR VGND VPWR VGND sky130_ef_sc_hd__decap_12
XTAP_TAPCELL_ROW_12_138 VGND VPWR sky130_fd_sc_hd__tapvpwrvgnd_1
XTAP_TAPCELL_ROW_20_171 VGND VPWR sky130_fd_sc_hd__tapvpwrvgnd_1
XFILLER_12_83 VGND VGND VPWR VPWR sky130_fd_sc_hd__fill_1
XPHY_EDGE_ROW_25_Left_67 VGND VGND VPWR VPWR sky130_fd_sc_hd__decap_3
X_419_ _179_ _181_ _182_ _148_ VGND VGND VPWR VPWR _183_ sky130_fd_sc_hd__a22oi_1
XFILLER_17_39 VPWR VGND VPWR VGND sky130_ef_sc_hd__decap_12
XFILLER_33_27 VPWR VGND VPWR VGND sky130_ef_sc_hd__decap_12
XFILLER_2_194 VGND VGND VPWR VPWR sky130_fd_sc_hd__fill_2
XFILLER_0_97 VPWR VGND VPWR VGND sky130_ef_sc_hd__decap_12
XFILLER_0_109 VGND VGND VPWR VPWR sky130_fd_sc_hd__decap_3
XFILLER_28_27 VGND VGND VPWR VPWR sky130_fd_sc_hd__fill_1
XFILLER_38_157 VGND VGND VPWR VPWR sky130_fd_sc_hd__decap_4
XFILLER_22_3 VPWR VGND VPWR VGND sky130_ef_sc_hd__decap_12
XFILLER_14_29 VGND VGND VPWR VPWR sky130_fd_sc_hd__fill_1
XPHY_EDGE_ROW_28_Left_70 VGND VGND VPWR VPWR sky130_fd_sc_hd__decap_3
XPHY_EDGE_ROW_12_Left_54 VGND VGND VPWR VPWR sky130_fd_sc_hd__decap_3
XFILLER_39_15 VPWR VGND VPWR VGND sky130_ef_sc_hd__decap_12
XFILLER_29_113 VPWR VGND VPWR VGND sky130_ef_sc_hd__decap_12
XFILLER_29_157 VGND VGND VPWR VPWR sky130_fd_sc_hd__decap_3
XFILLER_37_190 VPWR VGND VPWR VGND sky130_ef_sc_hd__decap_12
X_598_ symmetric_preadders.add_pair0.gen_fa\[0\].fa.b symmetric_preadders.add_pair0.gen_fa\[0\].fa.a
+ VGND VGND VPWR VPWR _051_ sky130_fd_sc_hd__or2_1
XFILLER_35_105 VGND VGND VPWR VPWR sky130_fd_sc_hd__decap_6
X_667_ clknet_2_2__leaf_clk _047_ VGND VGND VPWR VPWR symmetric_preadders.add_pair0.gen_fa\[7\].fa.b
+ sky130_fd_sc_hd__dfxtp_1
XFILLER_6_41 VPWR VGND VPWR VGND sky130_ef_sc_hd__decap_12
XFILLER_6_85 VPWR VGND VPWR VGND sky130_ef_sc_hd__decap_12
XFILLER_41_27 VGND VGND VPWR VPWR sky130_fd_sc_hd__fill_1
XFILLER_41_49 VGND VGND VPWR VPWR sky130_fd_sc_hd__decap_3
XFILLER_1_237 VGND VGND VPWR VPWR sky130_fd_sc_hd__decap_8
X_383_ symmetric_preadders.add_pair1.gen_fa\[3\].fa.b symmetric_preadders.add_pair1.gen_fa\[3\].fa.a
+ VGND VGND VPWR VPWR _148_ sky130_fd_sc_hd__or2_1
XFILLER_17_149 VPWR VGND VPWR VGND sky130_ef_sc_hd__decap_12
X_452_ _148_ _179_ _182_ _180_ VGND VGND VPWR VPWR _215_ sky130_fd_sc_hd__a31o_1
XFILLER_25_160 VGND VGND VPWR VPWR sky130_fd_sc_hd__fill_1
XFILLER_25_193 VPWR VGND VPWR VGND sky130_ef_sc_hd__decap_12
XTAP_TAPCELL_ROW_27_199 VGND VPWR sky130_fd_sc_hd__tapvpwrvgnd_1
X_521_ _269_ _280_ VGND VGND VPWR VPWR _282_ sky130_fd_sc_hd__and2_1
XFILLER_40_163 VGND VGND VPWR VPWR sky130_fd_sc_hd__decap_6
XFILLER_40_141 VGND VGND VPWR VPWR sky130_fd_sc_hd__fill_1
XTAP_TAPCELL_ROW_2_97 VGND VPWR sky130_fd_sc_hd__tapvpwrvgnd_1
XFILLER_16_193 VGND VGND VPWR VPWR sky130_fd_sc_hd__decap_3
XFILLER_14_108 VGND VGND VPWR VPWR sky130_fd_sc_hd__decap_4
XFILLER_36_27 VGND VGND VPWR VPWR sky130_fd_sc_hd__fill_1
XFILLER_22_141 VPWR VGND VPWR VGND sky130_ef_sc_hd__decap_12
XFILLER_22_174 VPWR VGND VPWR VGND sky130_ef_sc_hd__decap_12
X_366_ _079_ _105_ VGND VGND VPWR VPWR _131_ sky130_fd_sc_hd__nand2_1
X_504_ _231_ _233_ _230_ VGND VGND VPWR VPWR _266_ sky130_fd_sc_hd__a21o_1
X_435_ symmetric_preadders.add_pair2.gen_fa\[6\].fa.b symmetric_preadders.add_pair2.gen_fa\[6\].fa.a
+ VGND VGND VPWR VPWR _198_ sky130_fd_sc_hd__and2_1
XFILLER_9_167 VGND VGND VPWR VPWR sky130_fd_sc_hd__fill_1
XTAP_TAPCELL_ROW_23_180 VGND VPWR sky130_fd_sc_hd__tapvpwrvgnd_1
XFILLER_3_86 VPWR VGND VPWR VGND sky130_ef_sc_hd__decap_12
XFILLER_22_29 VPWR VGND VPWR VGND sky130_ef_sc_hd__decap_12
XTAP_TAPCELL_ROW_6_115 VGND VPWR sky130_fd_sc_hd__tapvpwrvgnd_1
XTAP_TAPCELL_ROW_29_206 VGND VPWR sky130_fd_sc_hd__tapvpwrvgnd_1
XFILLER_6_115 VGND VGND VPWR VPWR sky130_fd_sc_hd__fill_1
XTAP_TAPCELL_ROW_12_139 VGND VPWR sky130_fd_sc_hd__tapvpwrvgnd_1
XPHY_EDGE_ROW_0_Left_42 VGND VGND VPWR VPWR sky130_fd_sc_hd__decap_3
XFILLER_33_225 VPWR VGND VPWR VGND sky130_ef_sc_hd__decap_12
X_349_ symmetric_preadders.add_pair1.gen_fa\[2\].fa.b symmetric_preadders.add_pair1.gen_fa\[2\].fa.a
+ VGND VGND VPWR VPWR _115_ sky130_fd_sc_hd__nand2_1
X_418_ _081_ _113_ _117_ _149_ _114_ VGND VGND VPWR VPWR _182_ sky130_fd_sc_hd__a311o_1
XFILLER_33_39 VPWR VGND VPWR VGND sky130_ef_sc_hd__decap_12
XFILLER_15_225 VPWR VGND VPWR VGND sky130_ef_sc_hd__decap_12
XTAP_TAPCELL_ROW_31_212 VGND VPWR sky130_fd_sc_hd__tapvpwrvgnd_1
XFILLER_18_61 VGND VGND VPWR VPWR sky130_fd_sc_hd__fill_1
XFILLER_18_72 VPWR VGND VPWR VGND sky130_ef_sc_hd__decap_12
XFILLER_15_3 VPWR VGND VPWR VGND sky130_ef_sc_hd__decap_12
XFILLER_30_29 VPWR VGND VPWR VGND sky130_ef_sc_hd__decap_12
XFILLER_39_27 VPWR VGND VPWR VGND sky130_ef_sc_hd__decap_12
XFILLER_29_125 VPWR VGND VPWR VGND sky130_ef_sc_hd__decap_12
XFILLER_29_169 VPWR VGND VPWR VGND sky130_ef_sc_hd__decap_12
XFILLER_29_71 VPWR VGND VPWR VGND sky130_ef_sc_hd__decap_12
X_597_ symmetric_preadders.add_pair0.gen_fa\[0\].fa.b symmetric_preadders.add_pair0.gen_fa\[0\].fa.a
+ VGND VGND VPWR VPWR _050_ sky130_fd_sc_hd__nand2_1
XFILLER_28_180 VPWR VGND VPWR VGND sky130_ef_sc_hd__decap_12
X_666_ clknet_2_2__leaf_clk _046_ VGND VGND VPWR VPWR symmetric_preadders.add_pair0.gen_fa\[6\].fa.b
+ sky130_fd_sc_hd__dfxtp_1
XFILLER_6_53 VGND VGND VPWR VPWR sky130_fd_sc_hd__decap_6
XFILLER_6_97 VGND VGND VPWR VPWR sky130_fd_sc_hd__fill_1
XFILLER_41_109 VGND VGND VPWR VPWR sky130_fd_sc_hd__decap_3
XFILLER_25_18 VGND VGND VPWR VPWR sky130_fd_sc_hd__decap_6
XFILLER_17_106 VGND VGND VPWR VPWR sky130_fd_sc_hd__decap_6
X_520_ _269_ _280_ VGND VGND VPWR VPWR _281_ sky130_fd_sc_hd__or2_1
X_382_ _107_ _144_ _145_ VGND VGND VPWR VPWR _147_ sky130_fd_sc_hd__nand3_1
X_451_ _211_ _213_ VGND VGND VPWR VPWR _214_ sky130_fd_sc_hd__nand2_1
XFILLER_40_197 VGND VGND VPWR VPWR sky130_fd_sc_hd__fill_1
XTAP_TAPCELL_ROW_2_98 VGND VPWR sky130_fd_sc_hd__tapvpwrvgnd_1
X_649_ clknet_2_2__leaf_clk _029_ VGND VGND VPWR VPWR symmetric_preadders.add_pair1.gen_fa\[5\].fa.a
+ sky130_fd_sc_hd__dfxtp_1
XFILLER_39_220 VGND VGND VPWR VPWR sky130_fd_sc_hd__decap_4
XFILLER_22_153 VPWR VGND VPWR VGND sky130_ef_sc_hd__decap_12
XFILLER_22_186 VGND VGND VPWR VPWR sky130_fd_sc_hd__fill_2
XTAP_TAPCELL_ROW_9_124 VGND VPWR sky130_fd_sc_hd__tapvpwrvgnd_1
X_503_ _262_ _264_ VGND VGND VPWR VPWR _265_ sky130_fd_sc_hd__nand2_1
XFILLER_9_146 VGND VGND VPWR VPWR sky130_fd_sc_hd__decap_3
XFILLER_9_113 VGND VGND VPWR VPWR sky130_fd_sc_hd__fill_2
X_365_ _067_ _078_ _105_ VGND VGND VPWR VPWR _130_ sky130_fd_sc_hd__a21o_1
XTAP_TAPCELL_ROW_15_148 VGND VPWR sky130_fd_sc_hd__tapvpwrvgnd_1
XTAP_TAPCELL_ROW_23_181 VGND VPWR sky130_fd_sc_hd__tapvpwrvgnd_1
XFILLER_26_61 VGND VGND VPWR VPWR sky130_fd_sc_hd__fill_2
XFILLER_26_83 VGND VGND VPWR VPWR sky130_fd_sc_hd__fill_1
X_434_ symmetric_preadders.add_pair2.gen_fa\[6\].fa.b symmetric_preadders.add_pair2.gen_fa\[6\].fa.a
+ VGND VGND VPWR VPWR _197_ sky130_fd_sc_hd__or2_1
XFILLER_3_98 VPWR VGND VPWR VGND sky130_ef_sc_hd__decap_12
XFILLER_27_212 VGND VGND VPWR VPWR sky130_fd_sc_hd__fill_2
XTAP_TAPCELL_ROW_29_207 VGND VPWR sky130_fd_sc_hd__tapvpwrvgnd_1
XFILLER_10_123 VGND VGND VPWR VPWR sky130_fd_sc_hd__fill_1
XFILLER_12_41 VPWR VGND VPWR VGND sky130_ef_sc_hd__decap_12
XPHY_EDGE_ROW_16_Right_16 VGND VGND VPWR VPWR sky130_fd_sc_hd__decap_3
XFILLER_33_237 VGND VGND VPWR VPWR sky130_fd_sc_hd__decap_8
X_348_ symmetric_preadders.add_pair1.gen_fa\[2\].fa.b symmetric_preadders.add_pair1.gen_fa\[2\].fa.a
+ VGND VGND VPWR VPWR _114_ sky130_fd_sc_hd__and2_1
X_417_ symmetric_preadders.add_pair1.gen_fa\[4\].fa.b symmetric_preadders.add_pair1.gen_fa\[4\].fa.a
+ VGND VGND VPWR VPWR _181_ sky130_fd_sc_hd__nand2_1
XPHY_EDGE_ROW_25_Right_25 VGND VGND VPWR VPWR sky130_fd_sc_hd__decap_3
XPHY_EDGE_ROW_34_Right_34 VGND VGND VPWR VPWR sky130_fd_sc_hd__decap_3
XFILLER_15_237 VGND VGND VPWR VPWR sky130_fd_sc_hd__decap_8
XFILLER_23_51 VGND VGND VPWR VPWR sky130_fd_sc_hd__decap_4
XFILLER_2_141 VGND VGND VPWR VPWR sky130_fd_sc_hd__decap_8
XFILLER_21_207 VGND VGND VPWR VPWR sky130_fd_sc_hd__fill_1
XTAP_TAPCELL_ROW_31_213 VGND VPWR sky130_fd_sc_hd__tapvpwrvgnd_1
XFILLER_9_86 VPWR VGND VPWR VGND sky130_ef_sc_hd__decap_12
XFILLER_28_29 VPWR VGND VPWR VGND sky130_ef_sc_hd__decap_12
XFILLER_20_240 VGND VGND VPWR VPWR sky130_fd_sc_hd__decap_6
XFILLER_34_83 VGND VGND VPWR VPWR sky130_fd_sc_hd__fill_1
XFILLER_39_39 VGND VGND VPWR VPWR sky130_fd_sc_hd__decap_8
XPHY_EDGE_ROW_2_Right_2 VGND VGND VPWR VPWR sky130_fd_sc_hd__decap_3
XFILLER_29_137 VPWR VGND VPWR VGND sky130_ef_sc_hd__decap_12
XFILLER_4_214 VGND VGND VPWR VPWR sky130_fd_sc_hd__decap_8
XFILLER_20_85 VGND VGND VPWR VPWR sky130_fd_sc_hd__decap_4
X_665_ clknet_2_2__leaf_clk _045_ VGND VGND VPWR VPWR symmetric_preadders.add_pair0.gen_fa\[5\].fa.b
+ sky130_fd_sc_hd__dfxtp_1
XFILLER_28_192 VGND VGND VPWR VPWR sky130_fd_sc_hd__decap_4
XFILLER_29_83 VPWR VGND VPWR VGND sky130_ef_sc_hd__decap_12
X_596_ symmetric_preadders.add_pair2.gen_fa\[0\].fa.b symmetric_preadders.add_pair2.gen_fa\[0\].fa.a
+ VGND VGND VPWR VPWR _049_ sky130_fd_sc_hd__xor2_2
XFILLER_41_29 VPWR VGND VPWR VGND sky130_ef_sc_hd__decap_12
XFILLER_34_195 VGND VGND VPWR VPWR sky130_fd_sc_hd__fill_1
XFILLER_40_176 VGND VGND VPWR VPWR sky130_fd_sc_hd__decap_3
X_381_ _107_ _145_ _144_ VGND VGND VPWR VPWR _146_ sky130_fd_sc_hd__a21o_1
X_450_ symmetric_preadders.add_pair1.gen_fa\[5\].fa.b symmetric_preadders.add_pair1.gen_fa\[5\].fa.a
+ VGND VGND VPWR VPWR _213_ sky130_fd_sc_hd__nand2_1
XTAP_TAPCELL_ROW_2_99 VGND VPWR sky130_fd_sc_hd__tapvpwrvgnd_1
X_648_ clknet_2_2__leaf_clk _028_ VGND VGND VPWR VPWR symmetric_preadders.add_pair1.gen_fa\[4\].fa.a
+ sky130_fd_sc_hd__dfxtp_1
X_579_ net22 net1 VGND VGND VPWR VPWR _032_ sky130_fd_sc_hd__and2b_1
XFILLER_36_29 VPWR VGND VPWR VGND sky130_ef_sc_hd__decap_12
XFILLER_22_110 VGND VGND VPWR VPWR sky130_fd_sc_hd__fill_1
XTAP_TAPCELL_ROW_9_125 VGND VPWR sky130_fd_sc_hd__tapvpwrvgnd_1
X_433_ _194_ _196_ VGND VGND VPWR VPWR coefficient_adder.add_final.gen_fa\[6\].fa.sum
+ sky130_fd_sc_hd__xnor2_1
X_502_ _263_ VGND VGND VPWR VPWR _264_ sky130_fd_sc_hd__inv_2
XFILLER_9_169 VGND VGND VPWR VPWR sky130_fd_sc_hd__decap_4
XFILLER_13_187 VGND VGND VPWR VPWR sky130_fd_sc_hd__fill_1
XTAP_TAPCELL_ROW_15_149 VGND VPWR sky130_fd_sc_hd__tapvpwrvgnd_1
X_364_ _128_ _129_ _098_ _125_ VGND VGND VPWR VPWR coefficient_adder.add_final.gen_fa\[4\].fa.sum
+ sky130_fd_sc_hd__o2bb2a_1
XTAP_TAPCELL_ROW_23_182 VGND VPWR sky130_fd_sc_hd__tapvpwrvgnd_1
XFILLER_3_55 VGND VGND VPWR VPWR sky130_fd_sc_hd__fill_1
XFILLER_6_139 VGND VGND VPWR VPWR sky130_fd_sc_hd__fill_1
XFILLER_12_53 VPWR VGND VPWR VGND sky130_ef_sc_hd__decap_12
XFILLER_18_224 VPWR VGND VPWR VGND sky130_ef_sc_hd__decap_12
XFILLER_18_246 VGND VGND VPWR VPWR sky130_fd_sc_hd__fill_1
X_416_ symmetric_preadders.add_pair1.gen_fa\[4\].fa.b symmetric_preadders.add_pair1.gen_fa\[4\].fa.a
+ VGND VGND VPWR VPWR _180_ sky130_fd_sc_hd__and2_1
X_347_ symmetric_preadders.add_pair1.gen_fa\[2\].fa.b symmetric_preadders.add_pair1.gen_fa\[2\].fa.a
+ VGND VGND VPWR VPWR _113_ sky130_fd_sc_hd__or2_1
XFILLER_38_3 VPWR VGND VPWR VGND sky130_ef_sc_hd__decap_12
XFILLER_5_194 VGND VGND VPWR VPWR sky130_fd_sc_hd__fill_1
XFILLER_23_85 VGND VGND VPWR VPWR sky130_fd_sc_hd__fill_2
XFILLER_2_197 VPWR VGND VPWR VGND sky130_ef_sc_hd__decap_12
XFILLER_9_21 VGND VGND VPWR VPWR sky130_fd_sc_hd__fill_1
XTAP_TAPCELL_ROW_31_214 VGND VPWR sky130_fd_sc_hd__tapvpwrvgnd_1
XFILLER_9_98 VPWR VGND VPWR VGND sky130_ef_sc_hd__decap_12
XFILLER_18_41 VPWR VGND VPWR VGND sky130_ef_sc_hd__decap_12
XFILLER_18_85 VPWR VGND VPWR VGND sky130_ef_sc_hd__decap_12
XFILLER_7_245 VGND VGND VPWR VPWR sky130_fd_sc_hd__fill_2
XFILLER_7_223 VGND VGND VPWR VPWR sky130_fd_sc_hd__fill_1
XFILLER_38_116 VGND VGND VPWR VPWR sky130_fd_sc_hd__fill_1
XFILLER_29_149 VGND VGND VPWR VPWR sky130_fd_sc_hd__decap_8
XFILLER_37_160 VGND VGND VPWR VPWR sky130_fd_sc_hd__decap_8
XFILLER_29_51 VGND VGND VPWR VPWR sky130_fd_sc_hd__fill_2
X_595_ symmetric_preadders.add_pair2.gen_fa\[0\].fa.b symmetric_preadders.add_pair2.gen_fa\[0\].fa.a
+ VGND VGND VPWR VPWR _048_ sky130_fd_sc_hd__nand2_1
X_664_ clknet_2_0__leaf_clk _044_ VGND VGND VPWR VPWR symmetric_preadders.add_pair0.gen_fa\[4\].fa.b
+ sky130_fd_sc_hd__dfxtp_1
XFILLER_29_95 VPWR VGND VPWR VGND sky130_ef_sc_hd__decap_12
XPHY_EDGE_ROW_16_Left_58 VGND VGND VPWR VPWR sky130_fd_sc_hd__decap_3
XFILLER_20_3 VPWR VGND VPWR VGND sky130_ef_sc_hd__decap_12
XFILLER_26_119 VGND VGND VPWR VPWR sky130_fd_sc_hd__fill_1
XFILLER_34_141 VPWR VGND VPWR VGND sky130_ef_sc_hd__decap_12
X_380_ _058_ _085_ _087_ _108_ _086_ VGND VGND VPWR VPWR _145_ sky130_fd_sc_hd__a311o_1
X_578_ net26 net29 VGND VGND VPWR VPWR _031_ sky130_fd_sc_hd__and2b_1
X_647_ clknet_2_0__leaf_clk _027_ VGND VGND VPWR VPWR symmetric_preadders.add_pair1.gen_fa\[3\].fa.a
+ sky130_fd_sc_hd__dfxtp_1
XFILLER_16_141 VGND VGND VPWR VPWR sky130_fd_sc_hd__decap_8
.ends
